* TI LM358B rated temperatures: section 5.5 limits and typical drift.
* TI SLOS068AB, October 2024. See TEST_README.md for provenance.
* PREVIEW: TI LM358B acceptance run pending.
.step temp list -40 25 85
.lib ../LM358B.txt
V_OSCC OScc 0 5
V_OSCM OScm 0 0
V_OST OSt 0 1.4
E_OSS OSbase OScm OSout OSt 1000
V_OSIP OScm OSip 0
V_OSIM OSbase OSim 0
X_OS OSip OSim OScc 0 OSout LM358B
B_vos vos 0 V={abs(V(OSim,OSip))}
B_ib ib 0 V={-(I(V_OSIP)+I(V_OSIM))/2}
B_ios ios 0 V={abs(I(V_OSIP)-I(V_OSIM))}
V_GLCC GLcc 0 15
V_GLCM GLcm 0 2
V_GLT GLt 0 1
E_GLS GLbase GLcm GLout GLt 1000
V_GLIP GLcm GLip 0
V_GLIM GLbase GLim 0
X_GL GLip GLim GLcc 0 GLout LM358B
R_GLL GLout 0 10000
V_GHCC GHcc 0 15
V_GHCM GHcm 0 2
V_GHT GHt 0 11
E_GHS GHbase GHcm GHout GHt 1000
V_GHIP GHcm GHip 0
V_GHIM GHbase GHim 0
X_GH GHip GHim GHcc 0 GHout LM358B
R_GHL GHout 0 10000
B_gain gain 0 V={abs(V(GHout,GLout))/max(abs(V(GHip,GHim)-V(GLip,GLim)),1p)}
V_CMLCC CMLcc 0 30
V_CMLCM CMLcm 0 0
V_CMLT CMLt 0 1.4
E_CMLS CMLbase CMLcm CMLout CMLt 1000
V_CMLIP CMLcm CMLip 0
V_CMLIM CMLbase CMLim 0
X_CML CMLip CMLim CMLcc 0 CMLout LM358B
V_CMHCC CMHcc 0 30
V_CMHCM CMHcm 0 28
V_CMHT CMHt 0 1.4
E_CMHS CMHbase CMHcm CMHout CMHt 1000
V_CMHIP CMHcm CMHip 0
V_CMHIM CMHbase CMHim 0
X_CMH CMHip CMHim CMHcc 0 CMHout LM358B
B_CML_err CML_err 0 V={abs(V(CMLim,CMLip))}
B_CMH_err CMH_err 0 V={abs(V(CMHim,CMHip))}
V_V30 v30 0 30
V_V5 v5 0 5
V_ONE one 0 1
X_H2 one 0 v30 0 h2 LM358B
R_H2 h2 0 2k
X_H10 one 0 v30 0 h10 LM358B
R_H10 h10 0 10k
X_LOW 0 one v5 0 low LM358B
R_LOW low 0 10k
B_actual_temp actual_temp 0 V={temp}
V_SCAN scan 0 0
.dc V_SCAN 0 1 1
.options reltol=1e-5 abstol=1e-12 vntol=1e-8 gmin=1e-12
.save V(CMH_err) V(CML_err) V(actual_temp) V(gain) V(h10) V(h2) V(ib) V(ios) V(low) V(vos)
.meas DC VOS_MAX AVG V(vos)
.meas DC VOS_NOMINAL_LINE AVG V(vos)
.meas DC IB_MAX AVG V(ib)
.meas DC IOS_MAX AVG V(ios)
.meas DC IOS_NOMINAL_LINE AVG V(ios)
.meas DC AOL_MIN AVG V(gain)
.meas DC CML_OFFSET_MAX AVG V(CML_err)
.meas DC CMH_OFFSET_MAX AVG V(CMH_err)
.meas DC VOH30_2K_MIN AVG V(h2)
.meas DC VOH30_10K_MIN AVG V(h10)
.meas DC VOL_MAX AVG V(low)
.meas DC ACTUAL_TEMP AVG V(actual_temp)
.end
