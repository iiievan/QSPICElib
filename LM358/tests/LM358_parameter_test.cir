* LM358 signed offset/drift parameter contract, not process guarantees
* onsemi LM358/D Rev.36, Sep 2024. See TEST_README.md for provenance.
* PREVIEW: no QSPICE run has been performed in this environment.
.step temp list 0 25 70
.lib ../LM358.txt
V_POSCC POScc 0 5
V_POSCM POScm 0 0
V_POST POSt 0 1.4
E_POSS POSbase POScm POSout POSt 1000
V_POSIP POScm POSip 0
V_POSIM POSbase POSim 0
X_POS POSip POSim POScc 0 POSout LM358 params: VOS25=2m DVOSDT=7u
V_NEGCC NEGcc 0 5
V_NEGCM NEGcm 0 0
V_NEGT NEGt 0 1.4
E_NEGS NEGbase NEGcm NEGout NEGt 1000
V_NEGIP NEGcm NEGip 0
V_NEGIM NEGbase NEGim 0
X_NEG NEGip NEGim NEGcc 0 NEGout LM358 params: VOS25=-2m DVOSDT=-7u
B_difference difference 0 V={V(POSim,POSip)-V(NEGim,NEGip)}
B_actual_temp actual_temp 0 V={temp}
V_SCAN scan 0 0
.dc V_SCAN 0 1 1
.options reltol=1e-5 abstol=1e-12 vntol=1e-8 gmin=1e-12
.save V(actual_temp) V(difference)
.meas DC SIGNED_OFFSET_SEPARATION AVG V(difference)
.meas DC ACTUAL_TEMP AVG V(actual_temp)
.end
