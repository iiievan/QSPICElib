* LM358B 3/5/15/30/32 V operation at rated endpoint temperatures
* TI SLOS068AB, October 2024. See TEST_README.md for provenance.
* PREVIEW: TI LM358B acceptance run pending.
.step temp list -40 25 85
.lib ../LM358B.txt
V_S3 S3cc 0 3
V_S3IN S3in 0 .5
X_S3 S3in S3out S3cc 0 S3out LM358B
R_S3 S3out 0 10k
B_S3_err S3_err 0 V={abs(V(S3out,S3in))}
V_S5 S5cc 0 5
V_S5IN S5in 0 .5
X_S5 S5in S5out S5cc 0 S5out LM358B
R_S5 S5out 0 10k
B_S5_err S5_err 0 V={abs(V(S5out,S5in))}
V_S15 S15cc 0 15
V_S15IN S15in 0 .5
X_S15 S15in S15out S15cc 0 S15out LM358B
R_S15 S15out 0 10k
B_S15_err S15_err 0 V={abs(V(S15out,S15in))}
V_S30 S30cc 0 30
V_S30IN S30in 0 .5
X_S30 S30in S30out S30cc 0 S30out LM358B
R_S30 S30out 0 10k
B_S30_err S30_err 0 V={abs(V(S30out,S30in))}
V_S36 S36cc 0 36
V_S36IN S36in 0 .5
X_S36 S36in S36out S36cc 0 S36out LM358B
R_S36 S36out 0 10k
B_S36_err S36_err 0 V={abs(V(S36out,S36in))}
B_actual_temp actual_temp 0 V={temp}
V_SCAN scan 0 0
.dc V_SCAN 0 1 1
.options reltol=1e-5 abstol=1e-12 vntol=1e-8 gmin=1e-12
.save V(S15_err) V(S30_err) V(S36_err) V(S3_err) V(S5_err) V(actual_temp)
.meas DC S3_FEEDBACK AVG V(S3_err)
.meas DC S5_FEEDBACK AVG V(S5_err)
.meas DC S15_FEEDBACK AVG V(S15_err)
.meas DC S30_FEEDBACK AVG V(S30_err)
.meas DC S36_FEEDBACK AVG V(S36_err)
.meas DC ACTUAL_TEMP AVG V(actual_temp)
.end
