* LM358 output swing/current table p.4; 25 C only
* onsemi LM358/D Rev.36, Sep 2024. See TEST_README.md for provenance.
* PREVIEW: no QSPICE run has been performed in this environment.
.temp 25
.lib ../LM358.txt
V_H5CC H5cc 0 5
V_H5P H5p 0 2
V_H5M H5m 0 1
X_H5 H5p H5m H5cc 0 H5out LM358
R_H5 H5out 0 2000
V_H30_2KCC H30_2Kcc 0 30
V_H30_2KP H30_2Kp 0 2
V_H30_2KM H30_2Km 0 1
X_H30_2K H30_2Kp H30_2Km H30_2Kcc 0 H30_2Kout LM358
R_H30_2K H30_2Kout 0 2000
V_H30_10KCC H30_10Kcc 0 30
V_H30_10KP H30_10Kp 0 2
V_H30_10KM H30_10Km 0 1
X_H30_10K H30_10Kp H30_10Km H30_10Kcc 0 H30_10Kout LM358
R_H30_10K H30_10Kout 0 10000
V_L5CC L5cc 0 5
V_L5P L5p 0 0
V_L5M L5m 0 1
X_L5 L5p L5m L5cc 0 L5out LM358
R_L5 L5out 0 10000
V_SRCCC SRCcc 0 15
V_SRCP SRCp 0 2
V_SRCM SRCm 0 1
V_SRCO SRCout 0 7.5
X_SRC SRCp SRCm SRCcc 0 SRCout LM358
B_SRC_i SRC_i 0 V={I(V_SRCO)}
V_SNKCC SNKcc 0 15
V_SNKP SNKp 0 1
V_SNKM SNKm 0 2
V_SNKO SNKout 0 7.5
X_SNK SNKp SNKm SNKcc 0 SNKout LM358
B_SNK_i SNK_i 0 V={-I(V_SNKO)}
V_LOWCC LOWcc 0 5
V_LOWP LOWp 0 0
V_LOWM LOWm 0 1
V_LOWO LOWout 0 0.2
X_LOW LOWp LOWm LOWcc 0 LOWout LM358
B_LOW_i LOW_i 0 V={-I(V_LOWO)}
V_SHORTCC SHORTcc 0 15
V_SHORTP SHORTp 0 2
V_SHORTM SHORTm 0 1
V_SHORTO SHORTout 0 0
X_SHORT SHORTp SHORTm SHORTcc 0 SHORTout LM358
B_SHORT_i SHORT_i 0 V={I(V_SHORTO)}
V_SCAN scan 0 0
.dc V_SCAN 0 1 1
.options reltol=1e-5 abstol=1e-12 vntol=1e-8 gmin=1e-12
.save V(H30_10Kout) V(H30_2Kout) V(H5out) V(L5out) V(LOW_i) V(SHORT_i) V(SNK_i) V(SRC_i)
.meas DC VOH5_TYP AVG V(H5out)
.meas DC VOH5_MIN AVG V(H5out)
.meas DC VOH30_2K_MIN AVG V(H30_2Kout)
.meas DC VOH30_10K_TYP AVG V(H30_10Kout)
.meas DC VOH30_10K_MIN AVG V(H30_10Kout)
.meas DC VOL_TYP AVG V(L5out)
.meas DC VOL_MAX AVG V(L5out)
.meas DC VOL_POLARITY AVG V(L5out)
.meas DC ISOURCE_TYP AVG V(SRC_i)
.meas DC ISOURCE_MIN AVG V(SRC_i)
.meas DC ISINK_TYP AVG V(SNK_i)
.meas DC ISINK_MIN AVG V(SNK_i)
.meas DC ISINK_200mV_TYP AVG V(LOW_i)
.meas DC ISINK_200mV_MIN AVG V(LOW_i)
.meas DC ISC_TYP AVG V(SHORT_i)
.meas DC ISC_MAX AVG V(SHORT_i)
.end
