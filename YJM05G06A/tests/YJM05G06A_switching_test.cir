* Yangjie tabulated typical 10-V resistive-load switching, TJ=25C.
* P: VDD=-30V, ID=-5A, RGEN=2.2ohm; 6ohm load gives 5A.
* N Rev.3.2: VDD=+30V, ID=2A, RGEN=3ohm; 15ohm gives 2A.
* The attached older Rev.2.0 also listed RL=1ohm, inconsistent with
* VDD=30V/ID=2A for a simple resistive load. See TEST_README.md.
.temp 25
.lib ../YJM05N06A.txt
.lib ../YJM05GP06A.txt
V_NDD ndd 0 30
R_NLOAD ndd nd 15
V_NDRV ndrv 0 PULSE(0 10 5u 1n 1n 1u 2m)
R_NG ndrv ng 3
M_NSW nd ng 0 0 YJM05N06A
V_PDD pdd 0 -30
R_PLOAD pdd pd 6
V_PDRV pdrv 0 PULSE(0 -10 5u 1n 1n 1u 2m)
R_PG pdrv pg 2.2
M_PSW pd pg 0 0 YJM05GP06A
B_PVD pvd 0 V={-V(pd)}
.options reltol=1e-5 abstol=1e-12 vntol=1e-8 gmin=1e-12
.tran 0 8u 0 100p
.meas TRAN N_TDON TRIG V(ndrv)=1 RISE=1 TARG V(nd)=27 FALL=1
.meas TRAN N_TR TRIG V(nd)=27 FALL=1 TARG V(nd)=3 FALL=1
.meas TRAN N_TDOFF TRIG V(ndrv)=9 FALL=1 TARG V(nd)=3 RISE=1
.meas TRAN N_TF TRIG V(nd)=3 RISE=1 TARG V(nd)=27 RISE=1
.meas TRAN P_TDON TRIG V(pdrv)=-1 FALL=1 TARG V(pvd)=27 FALL=1
.meas TRAN P_TR TRIG V(pvd)=27 FALL=1 TARG V(pvd)=3 FALL=1
.meas TRAN P_TDOFF TRIG V(pdrv)=-9 RISE=1 TARG V(pvd)=3 RISE=1
.meas TRAN P_TF TRIG V(pvd)=3 RISE=1 TARG V(pvd)=27 RISE=1
.end
