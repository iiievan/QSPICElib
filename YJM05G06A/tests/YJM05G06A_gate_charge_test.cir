* Yangjie typical Qg/Qgd at 10V, |VDS|=30V, TJ=25C.
* N Rev.3.2: ID=10A pulsed; P Rev.1.0: ID=5A.
* IG=1mA means 1us of charge time equals 1nC.
.temp 25
.lib ../YJM05N06A.txt
.lib ../YJM05GP06A.txt
.model DCLAMP D(IS=1m N=0.1 RS=10m CJO=0)
V_NDD ndd 0 30
I_NLOAD ndd nd 10
D_NCLAMP nd ndd DCLAMP
I_NG 0 ng PULSE(0 1m 0 1n 1n 100u 200u)
R_NG ng 0 1G
M_NQ nd ng 0 0 YJM05N06A
V_PDD pdd 0 -30
I_PLOAD pd pdd 5
D_PCLAMP pdd pd DCLAMP
I_PG pg 0 PULSE(0 1m 0 1n 1n 100u 200u)
R_PG pg 0 1G
M_PQ pd pg 0 0 YJM05GP06A
B_PVD pvd 0 V={-V(pd)}
.options reltol=1e-5 abstol=1e-12 vntol=1e-8 gmin=1e-12
.tran 0 80u 0 2n
.meas TRAN N_QG WHEN V(ng)=10 RISE=1
.meas TRAN P_QG WHEN V(pg)=-10 FALL=1
.meas TRAN N_QGD TRIG V(nd)=27 FALL=1 TARG V(nd)=3 FALL=1
.meas TRAN P_QGD TRIG V(pvd)=27 FALL=1 TARG V(pvd)=3 FALL=1
.end
