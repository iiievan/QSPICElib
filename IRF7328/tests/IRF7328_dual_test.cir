* SO8 wrapper smoke test: separate channels and paired drain pins.
.temp 25
.lib ../IRF7328.txt
V_DD dd 0 -15
R_D1 dd d1a 15
R_D2 dd d2b 15
V_G1 g1 0 PULSE(-10 0 10u 1n 1n 10u 40u)
V_G2 g2 0 PULSE(0 -10 10u 1n 1n 10u 40u)
* Pins: 1=S1,2=G1,3=S2,4=G2,5=D2a,6=D2b,7=D1a,8=D1b.
X_DUAL 0 g1 0 g2 d2a d2b d1a d1b IRF7328_SO8
.options reltol=1e-5 abstol=1e-12 vntol=1e-8 gmin=1e-12
.tran 0 20u 0 10n
.meas TRAN D1_ON AVG V(0,d1a) FROM=5u TO=8u
.meas TRAN D2_OFF AVG V(0,d2b) FROM=5u TO=8u
.meas TRAN D1_OFF AVG V(0,d1a) FROM=15u TO=18u
.meas TRAN D2_ON AVG V(0,d2b) FROM=15u TO=18u
.meas TRAN D1_PAIR MAX abs(V(d1a,d1b)) FROM=5u TO=8u
.meas TRAN D2_PAIR MAX abs(V(d2a,d2b)) FROM=15u TO=18u
.end
