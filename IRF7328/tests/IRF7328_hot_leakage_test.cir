* IDSS tabulated at TJ=70C (not 150C), VDS=-24V, VGS=0.
.temp 70
.lib ../IRF7328.txt
V_LEAK leak 0 -24
M_LEAK leak 0 0 0 IRF7328
B_LEAK idss 0 V={abs(I(V_LEAK))}
.options reltol=1e-5 abstol=1e-12 vntol=1e-8 gmin=1e-12
.tran 0 20u 0 50n
.meas TRAN IDSS_HOT_MAX AVG V(idss) FROM=15u TO=20u
.end
