* ============================================================================
* FDS4559 - COMPACT COMPLEMENTARY HALF-BRIDGE FREQUENCY TEST
*
* Purpose:
*   Verify that the FDS4559 model still performs complete high/low switching
*   in a generic half bridge at three useful PWM frequencies and across the
*   datasheet operating-junction-temperature range.
*
* Generic fixture (not an application recommendation):
*   VBUS = 30 V, load ~= 1 A, VGS = +/-10 V, RGEN = 6 ohm, dead time = 500 ns
*   Frequencies: 20 kHz, 100 kHz, 400 kHz
*   Junction temperatures: -55 C, +25 C, +175 C
*
* The 30 V / 1 A / 10 V / 6 ohm values mirror the switching-characteristic
* conditions on datasheet page 2.  The datasheet does NOT specify a maximum
* PWM frequency or switching times at -55/+175 C.  Therefore rail reach is a
* hard functional invariant, while edge-time limits are diagnostic WARNs.
*
* One bridge and nine stepped corners replace the former 7 x 6 sweep matrix.
* Only seven voltages required by .meas are saved, keeping .qraw small.
*
* QPOST limitation found by the first real run:
*   stepped parameters inside .meas PARAM and parameter-derived FROM/TO windows
*   may remain frozen at the first step.  Measurements below therefore use the
*   complete transient and echo CORNER through a physical DC voltage source.
* ============================================================================

.param VBUS=30
.param VDRV=10
.param ILOAD=1
.param RGEN=6
.param DEADTIME=500n
.param CORNER=1

* Corners 1..3: 20 kHz; 4..6: 100 kHz; 7..9: 400 kHz.
* Within each frequency group: -55 C, +25 C, +175 C.
.param FSW={if(CORNER<4,20k,if(CORNER<7,100k,400k))}
.param TJ={if(CORNER==1,-55,if(CORNER==2,25,if(CORNER==3,175,if(CORNER==4,-55,if(CORNER==5,25,if(CORNER==6,175,if(CORNER==7,-55,if(CORNER==8,25,175))))))))}
.param TPER={1/FSW}
.param TON={TPER/2-DEADTIME}
.param TSTART={TPER}
.param RLOAD={VBUS/(2*ILOAD)}
.param TMAX=50n

.step param CORNER list 1 2 3 4 5 6 7 8 9

V_BUS    vb 0 {VBUS}
V_REF    vr 0 {VBUS/2}
V_CORNER corner_echo 0 {CORNER}

* P-channel drive: V(vb,pdrv) pulses 0 -> 10 V, so the gate goes 30 -> 20 V.
V_GP     vb pdrv PULSE(0 {VDRV} {TSTART} 1n 1n {TON} {TPER})
R_GP     pdrv pg {RGEN}

* N-channel starts after half a period.  TON leaves commanded dead time.
V_GN     ndrv 0 PULSE(0 {VDRV} {TSTART+TPER/2} 1n 1n {TON} {TPER})
R_GN     ndrv ng {RGEN}

M_P      sw pg vb vb FDS4559_P temp={TJ}
M_N      sw ng 0  0  FDS4559_N temp={TJ}
R_LOAD   sw vr {RLOAD}

.lib ../FDS4559_N.txt
.lib ../FDS4559_P.txt
.options reltol=1e-5 abstol=1e-12 vntol=1e-8 gmin=1e-12
.tran 0 {TSTART+3*TPER} 0 {TMAX}

* Keep QPOST input deliberately small.
.save V(vb) V(pdrv) V(pg) V(ndrv) V(ng) V(sw) V(corner_echo)

* A measured physical node avoids frozen .meas PARAM expressions.
.meas TRAN ECHO_CORNER AVG V(corner_echo)

* Full-transient extrema are safe here: the initial 0/15-V state cannot make
* any of these four limits pass accidentally.
.meas TRAN HB_P_VSG_PK MAX V(vb,pg)
.meas TRAN HB_N_VGS_PK MAX V(ng)
.meas TRAN HB_SW_MAX    MAX V(sw)
.meas TRAN HB_SW_MIN    MIN V(sw)

* Measure from the 50% driver-command crossing, ahead of RGEN, to the output
* rail.  This matches the intent of datasheet switching-delay measurements,
* excludes the deliberate 500-ns dead time and prevents QPOST from pairing
* a trigger in one cycle with a target in another cycle.
.meas TRAN HB_TO_HIGH     TRIG V(vb,pdrv)={VDRV/2} RISE=1 TARG V(sw)={0.9*VBUS} RISE=1
.meas TRAN HB_TO_HIGH_POS TRIG V(vb,pdrv)={VDRV/2} RISE=1 TARG V(sw)={0.9*VBUS} RISE=1
.meas TRAN HB_TO_LOW      TRIG V(ndrv)={VDRV/2}    RISE=1 TARG V(sw)={0.1*VBUS} FALL=1
.meas TRAN HB_TO_LOW_POS  TRIG V(ndrv)={VDRV/2}    RISE=1 TARG V(sw)={0.1*VBUS} FALL=1

.plot V(sw) V(vb,pg) V(ng)
.end
