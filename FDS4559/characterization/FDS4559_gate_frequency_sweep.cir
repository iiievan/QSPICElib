* ============================================================================
* FDS4559 - UNIVERSAL HALF-BRIDGE GATE/FREQUENCY CHARACTERIZATION
*
* Purpose: characterize the complementary FDS4559 itself as a half bridge
* versus external gate resistance and switching frequency, without any
* project-specific driver IC, supply rail or motor model.
*
* Fixture (deliberately generic):
*   VBUS   = 30 V (50% of 60-V rating; editable fixture parameter)
*   load   = resistive to VBUS/2, about 1 A in either bridge state
*   N gate = ideal 0/5 V source through Rg_ext
*   P gate = ideal 0/-10 V VGS equivalent source through Rg_ext
*   DT     = 500 ns commanded dead time
*   FSW    = 10...400 kHz (.step)
*
* Seven independent bridge copies use Rg_ext = 10,22,47,100,220,470,1000 ohm.
* Each frequency step therefore characterizes all Rg values in one run.
*
* Performance note:
*   Only the signals required by .meas are saved to .qraw.
*   Three cycles are simulated; measurements use the 2nd/3rd cycles.
*   TMAX=50 ns limits flat-region point density while QSPICE still
*   adapts to the 1-ns gate edges and nonlinear switching events.
*
* IMPORTANT MODEL LIMITATIONS: see characterization/README.md.
* In particular Qrr/trr, package inductance, driver output impedance and
* self-heating are NOT validated by this fixture. Dead-time results are
* gate/capacitance-limited model results, not a hardware-safe final value.
* ============================================================================

.param VBUS=30
.param VDRV_N=5
.param VDRV_P=10
.param ILOAD=1
.param DT=500n
.param TSTART=5u
.param FSW=20k
.param TPER={1/FSW}
.param TON={TPER/2-DT}
.param RLOAD={VBUS/(2*ILOAD)}
.param VTH_N=2.5
.param VTH_P=2.0
.param TMAX=50n

.step param FSW list 10k 20k 50k 100k 200k 400k

*** --- R0010: Rg_ext = 10 ohm on both gates ------------------------------
V_BUS_R0010   vb_R0010 0 {VBUS}
V_REF_R0010   vr_R0010 0 {VBUS/2}
V_GP_R0010    vb_R0010 pd_R0010 PULSE(0 {VDRV_P} {TSTART} 1n 1n {TON} {TPER})
V_GN_R0010    nd_R0010 0 PULSE(0 {VDRV_N} {TSTART+TPER/2} 1n 1n {TON} {TPER})
R_GP_R0010    pd_R0010 pg_R0010 10
R_GN_R0010    nd_R0010 ng_R0010 10
V_SP_R0010    vb_R0010 ps_R0010 0
V_SN_R0010    ns_R0010 0 0
M_P_R0010     sw_R0010 pg_R0010 ps_R0010 ps_R0010 FDS4559_P
M_N_R0010     sw_R0010 ng_R0010 ns_R0010 ns_R0010 FDS4559_N
R_LOAD_R0010  sw_R0010 vr_R0010 {RLOAD}

*** --- R0022: Rg_ext = 22 ohm on both gates ------------------------------
V_BUS_R0022   vb_R0022 0 {VBUS}
V_REF_R0022   vr_R0022 0 {VBUS/2}
V_GP_R0022    vb_R0022 pd_R0022 PULSE(0 {VDRV_P} {TSTART} 1n 1n {TON} {TPER})
V_GN_R0022    nd_R0022 0 PULSE(0 {VDRV_N} {TSTART+TPER/2} 1n 1n {TON} {TPER})
R_GP_R0022    pd_R0022 pg_R0022 22
R_GN_R0022    nd_R0022 ng_R0022 22
V_SP_R0022    vb_R0022 ps_R0022 0
V_SN_R0022    ns_R0022 0 0
M_P_R0022     sw_R0022 pg_R0022 ps_R0022 ps_R0022 FDS4559_P
M_N_R0022     sw_R0022 ng_R0022 ns_R0022 ns_R0022 FDS4559_N
R_LOAD_R0022  sw_R0022 vr_R0022 {RLOAD}

*** --- R0047: Rg_ext = 47 ohm on both gates ------------------------------
V_BUS_R0047   vb_R0047 0 {VBUS}
V_REF_R0047   vr_R0047 0 {VBUS/2}
V_GP_R0047    vb_R0047 pd_R0047 PULSE(0 {VDRV_P} {TSTART} 1n 1n {TON} {TPER})
V_GN_R0047    nd_R0047 0 PULSE(0 {VDRV_N} {TSTART+TPER/2} 1n 1n {TON} {TPER})
R_GP_R0047    pd_R0047 pg_R0047 47
R_GN_R0047    nd_R0047 ng_R0047 47
V_SP_R0047    vb_R0047 ps_R0047 0
V_SN_R0047    ns_R0047 0 0
M_P_R0047     sw_R0047 pg_R0047 ps_R0047 ps_R0047 FDS4559_P
M_N_R0047     sw_R0047 ng_R0047 ns_R0047 ns_R0047 FDS4559_N
R_LOAD_R0047  sw_R0047 vr_R0047 {RLOAD}

*** --- R0100: Rg_ext = 100 ohm on both gates ------------------------------
V_BUS_R0100   vb_R0100 0 {VBUS}
V_REF_R0100   vr_R0100 0 {VBUS/2}
V_GP_R0100    vb_R0100 pd_R0100 PULSE(0 {VDRV_P} {TSTART} 1n 1n {TON} {TPER})
V_GN_R0100    nd_R0100 0 PULSE(0 {VDRV_N} {TSTART+TPER/2} 1n 1n {TON} {TPER})
R_GP_R0100    pd_R0100 pg_R0100 100
R_GN_R0100    nd_R0100 ng_R0100 100
V_SP_R0100    vb_R0100 ps_R0100 0
V_SN_R0100    ns_R0100 0 0
M_P_R0100     sw_R0100 pg_R0100 ps_R0100 ps_R0100 FDS4559_P
M_N_R0100     sw_R0100 ng_R0100 ns_R0100 ns_R0100 FDS4559_N
R_LOAD_R0100  sw_R0100 vr_R0100 {RLOAD}

*** --- R0220: Rg_ext = 220 ohm on both gates ------------------------------
V_BUS_R0220   vb_R0220 0 {VBUS}
V_REF_R0220   vr_R0220 0 {VBUS/2}
V_GP_R0220    vb_R0220 pd_R0220 PULSE(0 {VDRV_P} {TSTART} 1n 1n {TON} {TPER})
V_GN_R0220    nd_R0220 0 PULSE(0 {VDRV_N} {TSTART+TPER/2} 1n 1n {TON} {TPER})
R_GP_R0220    pd_R0220 pg_R0220 220
R_GN_R0220    nd_R0220 ng_R0220 220
V_SP_R0220    vb_R0220 ps_R0220 0
V_SN_R0220    ns_R0220 0 0
M_P_R0220     sw_R0220 pg_R0220 ps_R0220 ps_R0220 FDS4559_P
M_N_R0220     sw_R0220 ng_R0220 ns_R0220 ns_R0220 FDS4559_N
R_LOAD_R0220  sw_R0220 vr_R0220 {RLOAD}

*** --- R0470: Rg_ext = 470 ohm on both gates ------------------------------
V_BUS_R0470   vb_R0470 0 {VBUS}
V_REF_R0470   vr_R0470 0 {VBUS/2}
V_GP_R0470    vb_R0470 pd_R0470 PULSE(0 {VDRV_P} {TSTART} 1n 1n {TON} {TPER})
V_GN_R0470    nd_R0470 0 PULSE(0 {VDRV_N} {TSTART+TPER/2} 1n 1n {TON} {TPER})
R_GP_R0470    pd_R0470 pg_R0470 470
R_GN_R0470    nd_R0470 ng_R0470 470
V_SP_R0470    vb_R0470 ps_R0470 0
V_SN_R0470    ns_R0470 0 0
M_P_R0470     sw_R0470 pg_R0470 ps_R0470 ps_R0470 FDS4559_P
M_N_R0470     sw_R0470 ng_R0470 ns_R0470 ns_R0470 FDS4559_N
R_LOAD_R0470  sw_R0470 vr_R0470 {RLOAD}

*** --- R1000: Rg_ext = 1000 ohm on both gates ------------------------------
V_BUS_R1000   vb_R1000 0 {VBUS}
V_REF_R1000   vr_R1000 0 {VBUS/2}
V_GP_R1000    vb_R1000 pd_R1000 PULSE(0 {VDRV_P} {TSTART} 1n 1n {TON} {TPER})
V_GN_R1000    nd_R1000 0 PULSE(0 {VDRV_N} {TSTART+TPER/2} 1n 1n {TON} {TPER})
R_GP_R1000    pd_R1000 pg_R1000 1000
R_GN_R1000    nd_R1000 ng_R1000 1000
V_SP_R1000    vb_R1000 ps_R1000 0
V_SN_R1000    ns_R1000 0 0
M_P_R1000     sw_R1000 pg_R1000 ps_R1000 ps_R1000 FDS4559_P
M_N_R1000     sw_R1000 ng_R1000 ns_R1000 ns_R1000 FDS4559_N
R_LOAD_R1000  sw_R1000 vr_R1000 {RLOAD}

.lib ../FDS4559_N.txt
.lib ../FDS4559_P.txt

.options reltol=1e-5 abstol=1e-12 vntol=1e-8 gmin=1e-12
.tran 0 {TSTART+3*TPER} 0 {TMAX}

* Save only data required by QPOST/.meas.  Without .save QSPICE also stores
* many device/internal traces; for this stepped switching bench that can make
* .qraw hundreds of megabytes and QPOST look hung.
.save V(pd_R0010) V(pg_R0010) V(nd_R0010) V(ng_R0010) V(ps_R0010) V(ns_R0010) V(sw_R0010)
.save I(V_BUS_R0010) I(V_SP_R0010) I(V_SN_R0010) I(R_GP_R0010) I(R_GN_R0010)
.save V(pd_R0022) V(pg_R0022) V(nd_R0022) V(ng_R0022) V(ps_R0022) V(ns_R0022) V(sw_R0022)
.save I(V_BUS_R0022) I(V_SP_R0022) I(V_SN_R0022) I(R_GP_R0022) I(R_GN_R0022)
.save V(pd_R0047) V(pg_R0047) V(nd_R0047) V(ng_R0047) V(ps_R0047) V(ns_R0047) V(sw_R0047)
.save I(V_BUS_R0047) I(V_SP_R0047) I(V_SN_R0047) I(R_GP_R0047) I(R_GN_R0047)
.save V(pd_R0100) V(pg_R0100) V(nd_R0100) V(ng_R0100) V(ps_R0100) V(ns_R0100) V(sw_R0100)
.save I(V_BUS_R0100) I(V_SP_R0100) I(V_SN_R0100) I(R_GP_R0100) I(R_GN_R0100)
.save V(pd_R0220) V(pg_R0220) V(nd_R0220) V(ng_R0220) V(ps_R0220) V(ns_R0220) V(sw_R0220)
.save I(V_BUS_R0220) I(V_SP_R0220) I(V_SN_R0220) I(R_GP_R0220) I(R_GN_R0220)
.save V(pd_R0470) V(pg_R0470) V(nd_R0470) V(ng_R0470) V(ps_R0470) V(ns_R0470) V(sw_R0470)
.save I(V_BUS_R0470) I(V_SP_R0470) I(V_SN_R0470) I(R_GP_R0470) I(R_GN_R0470)
.save V(pd_R1000) V(pg_R1000) V(nd_R1000) V(ng_R1000) V(ps_R1000) V(ns_R1000) V(sw_R1000)
.save I(V_BUS_R1000) I(V_SP_R1000) I(V_SN_R1000) I(R_GP_R1000) I(R_GN_R1000)

* Measurements are taken after startup, on later cycles.
* Gate timing uses the nominal threshold region only as a repeatable marker.
* Positive DT_PN/DT_NP means a gate-threshold gap; <=0 indicates overlap.

.meas TRAN R0010_P_VSG_PK MAX V(ps_R0010,pg_R0010) FROM={TSTART+TPER} TO={TSTART+3*TPER}
.meas TRAN R0010_N_VGS_PK MAX V(ng_R0010,ns_R0010) FROM={TSTART+TPER} TO={TSTART+3*TPER}
.meas TRAN R0010_SW_MAX MAX V(sw_R0010) FROM={TSTART+TPER} TO={TSTART+3*TPER}
.meas TRAN R0010_SW_MIN MIN V(sw_R0010) FROM={TSTART+TPER} TO={TSTART+3*TPER}
.meas TRAN R0010_IBUS_PK MAX -I(V_BUS_R0010) FROM={TSTART+TPER} TO={TSTART+3*TPER}
.meas TRAN R0010_PGATE AVG V(pd_R0010,pg_R0010)*I(R_GP_R0010) FROM={TSTART+TPER} TO={TSTART+3*TPER}
.meas TRAN R0010_NGATE AVG V(nd_R0010,ng_R0010)*I(R_GN_R0010) FROM={TSTART+TPER} TO={TSTART+3*TPER}
.meas TRAN R0010_PFET AVG abs(V(ps_R0010,sw_R0010)*I(V_SP_R0010)) FROM={TSTART+TPER} TO={TSTART+3*TPER}
.meas TRAN R0010_NFET AVG abs(V(sw_R0010,ns_R0010)*I(V_SN_R0010)) FROM={TSTART+TPER} TO={TSTART+3*TPER}
.meas TRAN R0010_P_TR TRIG V(ps_R0010,pg_R0010)=1 RISE=2 TARG V(ps_R0010,pg_R0010)=9 RISE=2
.meas TRAN R0010_P_TF TRIG V(ps_R0010,pg_R0010)=9 FALL=2 TARG V(ps_R0010,pg_R0010)=1 FALL=2
.meas TRAN R0010_N_TR TRIG V(ng_R0010,ns_R0010)=0.5 RISE=2 TARG V(ng_R0010,ns_R0010)=4.5 RISE=2
.meas TRAN R0010_N_TF TRIG V(ng_R0010,ns_R0010)=4.5 FALL=2 TARG V(ng_R0010,ns_R0010)=0.5 FALL=2
.meas TRAN R0010_SW_TR TRIG V(sw_R0010)={0.1*VBUS} RISE=2 TARG V(sw_R0010)={0.9*VBUS} RISE=2
.meas TRAN R0010_SW_TF TRIG V(sw_R0010)={0.9*VBUS} FALL=2 TARG V(sw_R0010)={0.1*VBUS} FALL=2
.meas TRAN R0010_DT_PN TRIG V(ps_R0010,pg_R0010)={VTH_P} FALL=2 TARG V(ng_R0010,ns_R0010)={VTH_N} RISE=2
.meas TRAN R0010_DT_NP TRIG V(ng_R0010,ns_R0010)={VTH_N} FALL=2 TARG V(ps_R0010,pg_R0010)={VTH_P} RISE=3

.meas TRAN R0022_P_VSG_PK MAX V(ps_R0022,pg_R0022) FROM={TSTART+TPER} TO={TSTART+3*TPER}
.meas TRAN R0022_N_VGS_PK MAX V(ng_R0022,ns_R0022) FROM={TSTART+TPER} TO={TSTART+3*TPER}
.meas TRAN R0022_SW_MAX MAX V(sw_R0022) FROM={TSTART+TPER} TO={TSTART+3*TPER}
.meas TRAN R0022_SW_MIN MIN V(sw_R0022) FROM={TSTART+TPER} TO={TSTART+3*TPER}
.meas TRAN R0022_IBUS_PK MAX -I(V_BUS_R0022) FROM={TSTART+TPER} TO={TSTART+3*TPER}
.meas TRAN R0022_PGATE AVG V(pd_R0022,pg_R0022)*I(R_GP_R0022) FROM={TSTART+TPER} TO={TSTART+3*TPER}
.meas TRAN R0022_NGATE AVG V(nd_R0022,ng_R0022)*I(R_GN_R0022) FROM={TSTART+TPER} TO={TSTART+3*TPER}
.meas TRAN R0022_PFET AVG abs(V(ps_R0022,sw_R0022)*I(V_SP_R0022)) FROM={TSTART+TPER} TO={TSTART+3*TPER}
.meas TRAN R0022_NFET AVG abs(V(sw_R0022,ns_R0022)*I(V_SN_R0022)) FROM={TSTART+TPER} TO={TSTART+3*TPER}
.meas TRAN R0022_P_TR TRIG V(ps_R0022,pg_R0022)=1 RISE=2 TARG V(ps_R0022,pg_R0022)=9 RISE=2
.meas TRAN R0022_P_TF TRIG V(ps_R0022,pg_R0022)=9 FALL=2 TARG V(ps_R0022,pg_R0022)=1 FALL=2
.meas TRAN R0022_N_TR TRIG V(ng_R0022,ns_R0022)=0.5 RISE=2 TARG V(ng_R0022,ns_R0022)=4.5 RISE=2
.meas TRAN R0022_N_TF TRIG V(ng_R0022,ns_R0022)=4.5 FALL=2 TARG V(ng_R0022,ns_R0022)=0.5 FALL=2
.meas TRAN R0022_SW_TR TRIG V(sw_R0022)={0.1*VBUS} RISE=2 TARG V(sw_R0022)={0.9*VBUS} RISE=2
.meas TRAN R0022_SW_TF TRIG V(sw_R0022)={0.9*VBUS} FALL=2 TARG V(sw_R0022)={0.1*VBUS} FALL=2
.meas TRAN R0022_DT_PN TRIG V(ps_R0022,pg_R0022)={VTH_P} FALL=2 TARG V(ng_R0022,ns_R0022)={VTH_N} RISE=2
.meas TRAN R0022_DT_NP TRIG V(ng_R0022,ns_R0022)={VTH_N} FALL=2 TARG V(ps_R0022,pg_R0022)={VTH_P} RISE=3

.meas TRAN R0047_P_VSG_PK MAX V(ps_R0047,pg_R0047) FROM={TSTART+TPER} TO={TSTART+3*TPER}
.meas TRAN R0047_N_VGS_PK MAX V(ng_R0047,ns_R0047) FROM={TSTART+TPER} TO={TSTART+3*TPER}
.meas TRAN R0047_SW_MAX MAX V(sw_R0047) FROM={TSTART+TPER} TO={TSTART+3*TPER}
.meas TRAN R0047_SW_MIN MIN V(sw_R0047) FROM={TSTART+TPER} TO={TSTART+3*TPER}
.meas TRAN R0047_IBUS_PK MAX -I(V_BUS_R0047) FROM={TSTART+TPER} TO={TSTART+3*TPER}
.meas TRAN R0047_PGATE AVG V(pd_R0047,pg_R0047)*I(R_GP_R0047) FROM={TSTART+TPER} TO={TSTART+3*TPER}
.meas TRAN R0047_NGATE AVG V(nd_R0047,ng_R0047)*I(R_GN_R0047) FROM={TSTART+TPER} TO={TSTART+3*TPER}
.meas TRAN R0047_PFET AVG abs(V(ps_R0047,sw_R0047)*I(V_SP_R0047)) FROM={TSTART+TPER} TO={TSTART+3*TPER}
.meas TRAN R0047_NFET AVG abs(V(sw_R0047,ns_R0047)*I(V_SN_R0047)) FROM={TSTART+TPER} TO={TSTART+3*TPER}
.meas TRAN R0047_P_TR TRIG V(ps_R0047,pg_R0047)=1 RISE=2 TARG V(ps_R0047,pg_R0047)=9 RISE=2
.meas TRAN R0047_P_TF TRIG V(ps_R0047,pg_R0047)=9 FALL=2 TARG V(ps_R0047,pg_R0047)=1 FALL=2
.meas TRAN R0047_N_TR TRIG V(ng_R0047,ns_R0047)=0.5 RISE=2 TARG V(ng_R0047,ns_R0047)=4.5 RISE=2
.meas TRAN R0047_N_TF TRIG V(ng_R0047,ns_R0047)=4.5 FALL=2 TARG V(ng_R0047,ns_R0047)=0.5 FALL=2
.meas TRAN R0047_SW_TR TRIG V(sw_R0047)={0.1*VBUS} RISE=2 TARG V(sw_R0047)={0.9*VBUS} RISE=2
.meas TRAN R0047_SW_TF TRIG V(sw_R0047)={0.9*VBUS} FALL=2 TARG V(sw_R0047)={0.1*VBUS} FALL=2
.meas TRAN R0047_DT_PN TRIG V(ps_R0047,pg_R0047)={VTH_P} FALL=2 TARG V(ng_R0047,ns_R0047)={VTH_N} RISE=2
.meas TRAN R0047_DT_NP TRIG V(ng_R0047,ns_R0047)={VTH_N} FALL=2 TARG V(ps_R0047,pg_R0047)={VTH_P} RISE=3

.meas TRAN R0100_P_VSG_PK MAX V(ps_R0100,pg_R0100) FROM={TSTART+TPER} TO={TSTART+3*TPER}
.meas TRAN R0100_N_VGS_PK MAX V(ng_R0100,ns_R0100) FROM={TSTART+TPER} TO={TSTART+3*TPER}
.meas TRAN R0100_SW_MAX MAX V(sw_R0100) FROM={TSTART+TPER} TO={TSTART+3*TPER}
.meas TRAN R0100_SW_MIN MIN V(sw_R0100) FROM={TSTART+TPER} TO={TSTART+3*TPER}
.meas TRAN R0100_IBUS_PK MAX -I(V_BUS_R0100) FROM={TSTART+TPER} TO={TSTART+3*TPER}
.meas TRAN R0100_PGATE AVG V(pd_R0100,pg_R0100)*I(R_GP_R0100) FROM={TSTART+TPER} TO={TSTART+3*TPER}
.meas TRAN R0100_NGATE AVG V(nd_R0100,ng_R0100)*I(R_GN_R0100) FROM={TSTART+TPER} TO={TSTART+3*TPER}
.meas TRAN R0100_PFET AVG abs(V(ps_R0100,sw_R0100)*I(V_SP_R0100)) FROM={TSTART+TPER} TO={TSTART+3*TPER}
.meas TRAN R0100_NFET AVG abs(V(sw_R0100,ns_R0100)*I(V_SN_R0100)) FROM={TSTART+TPER} TO={TSTART+3*TPER}
.meas TRAN R0100_P_TR TRIG V(ps_R0100,pg_R0100)=1 RISE=2 TARG V(ps_R0100,pg_R0100)=9 RISE=2
.meas TRAN R0100_P_TF TRIG V(ps_R0100,pg_R0100)=9 FALL=2 TARG V(ps_R0100,pg_R0100)=1 FALL=2
.meas TRAN R0100_N_TR TRIG V(ng_R0100,ns_R0100)=0.5 RISE=2 TARG V(ng_R0100,ns_R0100)=4.5 RISE=2
.meas TRAN R0100_N_TF TRIG V(ng_R0100,ns_R0100)=4.5 FALL=2 TARG V(ng_R0100,ns_R0100)=0.5 FALL=2
.meas TRAN R0100_SW_TR TRIG V(sw_R0100)={0.1*VBUS} RISE=2 TARG V(sw_R0100)={0.9*VBUS} RISE=2
.meas TRAN R0100_SW_TF TRIG V(sw_R0100)={0.9*VBUS} FALL=2 TARG V(sw_R0100)={0.1*VBUS} FALL=2
.meas TRAN R0100_DT_PN TRIG V(ps_R0100,pg_R0100)={VTH_P} FALL=2 TARG V(ng_R0100,ns_R0100)={VTH_N} RISE=2
.meas TRAN R0100_DT_NP TRIG V(ng_R0100,ns_R0100)={VTH_N} FALL=2 TARG V(ps_R0100,pg_R0100)={VTH_P} RISE=3

.meas TRAN R0220_P_VSG_PK MAX V(ps_R0220,pg_R0220) FROM={TSTART+TPER} TO={TSTART+3*TPER}
.meas TRAN R0220_N_VGS_PK MAX V(ng_R0220,ns_R0220) FROM={TSTART+TPER} TO={TSTART+3*TPER}
.meas TRAN R0220_SW_MAX MAX V(sw_R0220) FROM={TSTART+TPER} TO={TSTART+3*TPER}
.meas TRAN R0220_SW_MIN MIN V(sw_R0220) FROM={TSTART+TPER} TO={TSTART+3*TPER}
.meas TRAN R0220_IBUS_PK MAX -I(V_BUS_R0220) FROM={TSTART+TPER} TO={TSTART+3*TPER}
.meas TRAN R0220_PGATE AVG V(pd_R0220,pg_R0220)*I(R_GP_R0220) FROM={TSTART+TPER} TO={TSTART+3*TPER}
.meas TRAN R0220_NGATE AVG V(nd_R0220,ng_R0220)*I(R_GN_R0220) FROM={TSTART+TPER} TO={TSTART+3*TPER}
.meas TRAN R0220_PFET AVG abs(V(ps_R0220,sw_R0220)*I(V_SP_R0220)) FROM={TSTART+TPER} TO={TSTART+3*TPER}
.meas TRAN R0220_NFET AVG abs(V(sw_R0220,ns_R0220)*I(V_SN_R0220)) FROM={TSTART+TPER} TO={TSTART+3*TPER}
.meas TRAN R0220_P_TR TRIG V(ps_R0220,pg_R0220)=1 RISE=2 TARG V(ps_R0220,pg_R0220)=9 RISE=2
.meas TRAN R0220_P_TF TRIG V(ps_R0220,pg_R0220)=9 FALL=2 TARG V(ps_R0220,pg_R0220)=1 FALL=2
.meas TRAN R0220_N_TR TRIG V(ng_R0220,ns_R0220)=0.5 RISE=2 TARG V(ng_R0220,ns_R0220)=4.5 RISE=2
.meas TRAN R0220_N_TF TRIG V(ng_R0220,ns_R0220)=4.5 FALL=2 TARG V(ng_R0220,ns_R0220)=0.5 FALL=2
.meas TRAN R0220_SW_TR TRIG V(sw_R0220)={0.1*VBUS} RISE=2 TARG V(sw_R0220)={0.9*VBUS} RISE=2
.meas TRAN R0220_SW_TF TRIG V(sw_R0220)={0.9*VBUS} FALL=2 TARG V(sw_R0220)={0.1*VBUS} FALL=2
.meas TRAN R0220_DT_PN TRIG V(ps_R0220,pg_R0220)={VTH_P} FALL=2 TARG V(ng_R0220,ns_R0220)={VTH_N} RISE=2
.meas TRAN R0220_DT_NP TRIG V(ng_R0220,ns_R0220)={VTH_N} FALL=2 TARG V(ps_R0220,pg_R0220)={VTH_P} RISE=3

.meas TRAN R0470_P_VSG_PK MAX V(ps_R0470,pg_R0470) FROM={TSTART+TPER} TO={TSTART+3*TPER}
.meas TRAN R0470_N_VGS_PK MAX V(ng_R0470,ns_R0470) FROM={TSTART+TPER} TO={TSTART+3*TPER}
.meas TRAN R0470_SW_MAX MAX V(sw_R0470) FROM={TSTART+TPER} TO={TSTART+3*TPER}
.meas TRAN R0470_SW_MIN MIN V(sw_R0470) FROM={TSTART+TPER} TO={TSTART+3*TPER}
.meas TRAN R0470_IBUS_PK MAX -I(V_BUS_R0470) FROM={TSTART+TPER} TO={TSTART+3*TPER}
.meas TRAN R0470_PGATE AVG V(pd_R0470,pg_R0470)*I(R_GP_R0470) FROM={TSTART+TPER} TO={TSTART+3*TPER}
.meas TRAN R0470_NGATE AVG V(nd_R0470,ng_R0470)*I(R_GN_R0470) FROM={TSTART+TPER} TO={TSTART+3*TPER}
.meas TRAN R0470_PFET AVG abs(V(ps_R0470,sw_R0470)*I(V_SP_R0470)) FROM={TSTART+TPER} TO={TSTART+3*TPER}
.meas TRAN R0470_NFET AVG abs(V(sw_R0470,ns_R0470)*I(V_SN_R0470)) FROM={TSTART+TPER} TO={TSTART+3*TPER}
.meas TRAN R0470_P_TR TRIG V(ps_R0470,pg_R0470)=1 RISE=2 TARG V(ps_R0470,pg_R0470)=9 RISE=2
.meas TRAN R0470_P_TF TRIG V(ps_R0470,pg_R0470)=9 FALL=2 TARG V(ps_R0470,pg_R0470)=1 FALL=2
.meas TRAN R0470_N_TR TRIG V(ng_R0470,ns_R0470)=0.5 RISE=2 TARG V(ng_R0470,ns_R0470)=4.5 RISE=2
.meas TRAN R0470_N_TF TRIG V(ng_R0470,ns_R0470)=4.5 FALL=2 TARG V(ng_R0470,ns_R0470)=0.5 FALL=2
.meas TRAN R0470_SW_TR TRIG V(sw_R0470)={0.1*VBUS} RISE=2 TARG V(sw_R0470)={0.9*VBUS} RISE=2
.meas TRAN R0470_SW_TF TRIG V(sw_R0470)={0.9*VBUS} FALL=2 TARG V(sw_R0470)={0.1*VBUS} FALL=2
.meas TRAN R0470_DT_PN TRIG V(ps_R0470,pg_R0470)={VTH_P} FALL=2 TARG V(ng_R0470,ns_R0470)={VTH_N} RISE=2
.meas TRAN R0470_DT_NP TRIG V(ng_R0470,ns_R0470)={VTH_N} FALL=2 TARG V(ps_R0470,pg_R0470)={VTH_P} RISE=3

.meas TRAN R1000_P_VSG_PK MAX V(ps_R1000,pg_R1000) FROM={TSTART+TPER} TO={TSTART+3*TPER}
.meas TRAN R1000_N_VGS_PK MAX V(ng_R1000,ns_R1000) FROM={TSTART+TPER} TO={TSTART+3*TPER}
.meas TRAN R1000_SW_MAX MAX V(sw_R1000) FROM={TSTART+TPER} TO={TSTART+3*TPER}
.meas TRAN R1000_SW_MIN MIN V(sw_R1000) FROM={TSTART+TPER} TO={TSTART+3*TPER}
.meas TRAN R1000_IBUS_PK MAX -I(V_BUS_R1000) FROM={TSTART+TPER} TO={TSTART+3*TPER}
.meas TRAN R1000_PGATE AVG V(pd_R1000,pg_R1000)*I(R_GP_R1000) FROM={TSTART+TPER} TO={TSTART+3*TPER}
.meas TRAN R1000_NGATE AVG V(nd_R1000,ng_R1000)*I(R_GN_R1000) FROM={TSTART+TPER} TO={TSTART+3*TPER}
.meas TRAN R1000_PFET AVG abs(V(ps_R1000,sw_R1000)*I(V_SP_R1000)) FROM={TSTART+TPER} TO={TSTART+3*TPER}
.meas TRAN R1000_NFET AVG abs(V(sw_R1000,ns_R1000)*I(V_SN_R1000)) FROM={TSTART+TPER} TO={TSTART+3*TPER}
.meas TRAN R1000_P_TR TRIG V(ps_R1000,pg_R1000)=1 RISE=2 TARG V(ps_R1000,pg_R1000)=9 RISE=2
.meas TRAN R1000_P_TF TRIG V(ps_R1000,pg_R1000)=9 FALL=2 TARG V(ps_R1000,pg_R1000)=1 FALL=2
.meas TRAN R1000_N_TR TRIG V(ng_R1000,ns_R1000)=0.5 RISE=2 TARG V(ng_R1000,ns_R1000)=4.5 RISE=2
.meas TRAN R1000_N_TF TRIG V(ng_R1000,ns_R1000)=4.5 FALL=2 TARG V(ng_R1000,ns_R1000)=0.5 FALL=2
.meas TRAN R1000_SW_TR TRIG V(sw_R1000)={0.1*VBUS} RISE=2 TARG V(sw_R1000)={0.9*VBUS} RISE=2
.meas TRAN R1000_SW_TF TRIG V(sw_R1000)={0.9*VBUS} FALL=2 TARG V(sw_R1000)={0.1*VBUS} FALL=2
.meas TRAN R1000_DT_PN TRIG V(ps_R1000,pg_R1000)={VTH_P} FALL=2 TARG V(ng_R1000,ns_R1000)={VTH_N} RISE=2
.meas TRAN R1000_DT_NP TRIG V(ng_R1000,ns_R1000)={VTH_N} FALL=2 TARG V(ps_R1000,pg_R1000)={VTH_P} RISE=3

.end
