* FJP5027 / gain_Tm25 / frozen model
* D:\2.github\QSPICElib\transistors\Si\transistor_common_cir_v1\bjt\01_output_gummel_leakage_dc.qsch
V_SCAN scan 0 0
V_CG cg_feed 0 {POL*VCE_GUMMEL}
V_ICG cg_feed c_gummel 0
B_VBE_DRIVE bg_drive 0 V={POL*(VBE_START+(VBE_STOP-VBE_START)*V(scan))}
V_IBG bg_drive b_gummel 0
X_GUMMEL c_gummel b_gummel 0 0 DUT_BJT
B_ICG ic_gummel 0 V={POL*I(V_ICG)}
B_IBG ib_gummel 0 V={POL*I(V_IBG)}
B_VBG vbe 0 V={POL*V(b_gummel)}
.temp -25
.param VCE_SWEEP=10
.param R_COLLECTOR=1
.param IB_TEST=100u
.param IC_SAT_REF=5m
.param VCE_GUMMEL=5
.param VBE_START=0.4
.param VBE_STOP=1.6
.param VBLOCK_SCAN=20
.param IB_FLOOR=1p
.param SCAN_STEP=0.00025
.options reltol=1e-5 abstol=1e-13 vntol=1e-8
.dc V_SCAN 0 1 {SCAN_STEP}
.param POL=1
* Independent MEXTRAM 504 starting/fitted candidate. Not vendor SPICE.

* Fit domain: isothermal DC at -25/25/75/125 C. Read the temperature report.

* Charge/transit/avalanche/thermal parameters are NOT extracted here.

* Self-heating is disabled by RTH=0; no transient thermal impedance is claimed.

.model FJP5027_MEXTRAM_DC25_CANDIDATE_V3 NPN(

+ AQBO=0.297244498617917 AE=0 AB=1.69400323062251 AEPI=0.296543736959778 AEX=0.62

+ AC=2 DAIS=0 DVGBF=0.0519988061991336 DVGBR=0.0167856373543117 LEVEL=504

+ TREF=25 IS=3.63204984302532e-14 BF=35.1710316296583 VEF=616.059961336148 VER=42.0423371846927

+ IK=1 IBF=4.8783379259058e-12 MLF=1.50881604259697 BRI=5.89566175149349 IBR=9.19790477411798e-11

+ RE=0.001 RBC=0.0163401988720245 RBV=0.03 RCC=0.00103037374248808 RCV=0.233274524452755

+ SCRCV=4.47264914309014 IHC=3.06109698521882 AXI=0.334508317760624 CJE=2e-09 CJC=1.4446e-10

+ PE=0.33 PC=0.33 VDE=0.75 VDC=0.75 TAUE=5e-09

+ TAUB=5e-09 VGB=1.24970987475881 VGC=1.11 VGJ=1.00691145909525 EXAVL=0

+ RTH=0)

.subckt DUT_BJT C B E K
Q_CORE C B E FJP5027_MEXTRAM_DC25_CANDIDATE_V3
R_K K E 1u
.ends DUT_BJT
B_HFE_CALC hfe_calc 0 V={if(V(ib_gummel)>1e-10,V(ic_gummel)/max(V(ib_gummel),1e-12),0)}
.meas DC HFE_0P2 FIND V(hfe_calc) WHEN V(ic_gummel)=0.2 CROSS=1
.meas DC HFE_1 FIND V(hfe_calc) WHEN V(ic_gummel)=1 CROSS=1
.end
