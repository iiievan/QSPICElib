* MEXTRAM crash diagnostic ONLY; no thermal parameter extraction
V_TEST c 0 SIN(10 1m 1Meg)
R_EOPEN e 0 1T
Q_TEST c 0 e FJP5027_MEXTRAM_DC25_CANDIDATE_V3
* Independent MEXTRAM 504 starting/fitted candidate. Not vendor SPICE.
* Domain of this extraction: isothermal DC at 25 C. Read the native report.
* Charge/transit/avalanche/thermal parameters are NOT extracted here.
* Self-heating is disabled by RTH=0; no transient thermal impedance is claimed.
.model FJP5027_MEXTRAM_DC25_CANDIDATE_V3 NPN(
+ LEVEL=504 TREF=25 IS=2.56212315717401e-14 BF=35.167556219634 VEF=618.404813872095
+ VER=42.0423371846927 IK=1 IBF=4.8783379259058e-12 MLF=1.50881604259697 BRI=6.35493387280118
+ IBR=9.19790477411798e-11 RE=0.001 RBC=0.0168490495318386 RBV=0.03 RCC=0.00103037374248808
+ RCV=0.260772065945659 SCRCV=6.65428944373425 IHC=3.80485836330227 AXI=0.334508317760624 CJE=2e-09
+ CJC=1.4446e-10 PE=0.33 PC=0.33 VDE=0.75 VDC=0.75
+ TAUE=5e-09 TAUB=5e-09 VGB=1.11 VGC=1.11 VGJ=1.11
+ EXAVL=0 RTH=0)

.temp 25
.options reltol=1e-5 abstol=1e-13 vntol=1e-8
B_PROJECTION proj 0 V={I(V_TEST)*cos(2*pi*1Meg*time)}
.tran 0 20u 0 2.5n
.meas TRAN COBO_COS INTEG V(proj) FROM=10u TO=20u
.end
