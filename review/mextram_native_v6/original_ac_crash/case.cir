* FJP5027 / cap_Tp25 / frozen model
* D:\2.github\QSPICElib\transistors\Si\transistor_common_cir_v1\bjt\02_junction_capacitance_ac.qsch
V_CO co_drive 0 DC {POL*VCB_BIAS} AC {AC_AMPL}
V_CO_SENSE co_drive c_out 0
R_EOPEN e_open 0 1T
X_CO c_out 0 e_open e_open DUT_BJT
V_CI ci_drive 0 {POL*VEB_BIAS} AC {AC_AMPL}
V_CI_SENSE ci_drive e_in 0
R_COPEN 0 c_open 1T
X_CI c_open 0 e_in e_in DUT_BJT
B_CO i_cobo 0 V={I(V_CO_SENSE)}
B_CI i_cibo 0 V={I(V_CI_SENSE)}
.temp 25
.param VCB_BIAS=10
.param VEB_BIAS=1
.param AC_AMPL=1
.param F_MIN=100000
.param F_MAX=10000000
.param F_TEST=1000000
.options reltol=1e-5 abstol=1e-13 vntol=1e-8
.ac dec 40 {F_MIN} {F_MAX}
.param POL=1
* Independent MEXTRAM 504 starting/fitted candidate. Not vendor SPICE.
* Domain of this extraction: isothermal DC at 25 C. Read the native report.
* Charge/transit/avalanche/thermal parameters are NOT extracted here.
* Self-heating is disabled by RTH=0; no transient thermal impedance is claimed.
.model FJP5027_MEXTRAM_DC25_CANDIDATE_V3 NPN(
+ LEVEL=504 TREF=25 IS=2.56212315717401e-14 BF=35.167556219634 VEF=618.404813872095
+ VER=42.0423371846927 IK=1 IBF=4.8783379259058e-12 MLF=1.50881604259697 BRI=6.35493387280118
+ IBR=9.19790477411798e-11 RE=0.001 RBC=0.0168490495318386 RBV=0.03 RCC=0.00103037374248808
+ RCV=0.260772065945659 SCRCV=6.65428944373425 IHC=3.80485836330227 AXI=0.334508317760624 CJE=2e-09
+ CJC=1.4446e-10 PE=0.33 PC=0.33 VDE=0.75 VDC=0.75
+ TAUE=5e-09 TAUB=5e-09 VGB=1.11 VGC=1.11 VGJ=1.11
+ EXAVL=0 RTH=0)

.subckt DUT_BJT C B E K
Q_CORE C B E FJP5027_MEXTRAM_DC25_CANDIDATE_V3
R_K K E 1u
.ends DUT_BJT
.meas AC COBO_I_IM FIND imag(V(i_cobo)) AT={F_TEST}
.meas AC CIBO_I_IM FIND imag(V(i_cibo)) AT={F_TEST}
.end
