* FJP5027 / inductive_Tp25_s2 / frozen model
* D:\2.github\QSPICElib\transistors\Si\transistor_common_cir_v1\bjt\04_clamped_inductive_tran.qsch
V_CC supply 0 {POL*VCC}
R_L supply l_feed {R_L}
L_LOAD l_feed clamp_node {L_LOAD}
V_IC clamp_node collector 0
X_DUT collector base 0 0 DUT_BJT
V_CLAMP clamp_rail 0 {POL*VCLAMP}
B_CLAMP clamp_node clamp_rail I={POL*max(POL*V(clamp_node,clamp_rail),0)/R_CLAMP}
V_CMD cmd 0 PWL(0 0 {T_DELAY} 0 {T_DELAY+T_EDGE} 1 {T_OFF} 1 {T_OFF+T_EDGE} 0)
V_NEG b_negative 0 {POL*VBE_OFF}
.model S_OFF•SW_OFF SW(Ron=1m Roff=1T Vt=0.5 Vh=0)
S_OFF b_drive b_pull off_command 0 S_OFF•SW_OFF
R_B_OFF b_pull b_negative {R_B_OFF}
R_B_ON b_drive b_feed {R_B_ON}
V_IB b_feed base 0
B_VCE vce 0 V={POL*V(collector)}
B_VBE vbe 0 V={POL*V(base)}
B_IC ic 0 V={POL*I(V_IC)}
B_IB ib 0 V={POL*I(V_IB)}
B_IL iload 0 V={POL*I(L_LOAD)}
B_CF ic_ratio 0 V={V(ic)/IC_REFERENCE}
B_PC p_collector 0 V={V(collector)*I(V_IC)}
B_PB p_base 0 V={V(base)*I(V_IB)}
B_IBSRC 0 b_drive I={POL*IB_ON*V(cmd)}
B_OFF off_command 0 V={1-V(cmd)}
.temp 25
.param VCC=20
.param VCLAMP=400
.param L_LOAD=0.002
.param R_L=0.1
.param IB_ON=0.3
.param R_B_ON=0.1
.param VBE_OFF=-2
.param R_B_OFF=1
.param R_CLAMP=0.01
.param IC_REFERENCE=1.5
.param T_DELAY=5e-06
.param TON=0.00015
.param T_EDGE=5e-09
.param T_TAIL=2e-05
.param ENERGY_WINDOW=5e-06
.param T_MAX=5e-10
.param T_OFF={T_DELAY+T_EDGE+TON}
.param T_STOP={T_OFF+T_EDGE+T_TAIL}
.options reltol=1e-5 abstol=1e-12 vntol=1e-8
.tran 0 {T_STOP} 0 {T_MAX}
.param POL=1
* FJP5027_CANDIDATE_V1: independently constructed STARTING model, not vendor SPICE.
* User-supplied Fairchild Rev.A December 2003 is the reference.
* NOT YET CALIBRATED OR VALIDATED IN QSPICE. Compare every curve in the report.
* DC seed: BF/IKF/VAF approximate mid-current gain and its high-current rolloff.
* CJC chosen to give approximately 60 pF at VCB=10V, f=1MHz, 25 C.
* TF is an initial estimate from fT=15MHz; TR/CJE/RB and dynamic accuracy UNVALIDATED.
* XTB/temperature and high-injection/saturation behavior are calibration targets.
* No avalanche, secondary breakdown, SOA, self-heating or thermal memory model.
* Voltage rating is documentation, NOT an implemented breakdown mechanism.
.model FJP5027_CANDIDATE_V1 NPN(
+ IS=10f NF=1 BF=30 IKF=0.8 VAF=50 ISE=1p NE=1.5
+ BR=2 NR=1 IKR=0.02 VAR=20 ISC=1p NC=1.5
+ RB=2 RBM=0.3 IRB=0.01 RC=0.2 RE=0.02
+ CJE=2n VJE=0.75 MJE=0.33 CJC=144.46p VJC=0.75 MJC=0.33
+ TF=10n TR=300n XTB=1.1 EG=1.11 XTI=3 TNOM=25)

.subckt DUT_BJT C B E K
Q_CORE C B E FJP5027_CANDIDATE_V1
R_K K E 1u
.ends DUT_BJT
.meas TRAN T_STORAGE_CMD TRIG V(cmd)=0.9 FALL=1 TARG V(ic_ratio)=0.9 FALL=1
.meas TRAN T_STORAGE_IB TRIG V(ib)=0 FALL=1 TARG V(ic_ratio)=0.9 FALL=1
.meas TRAN T_FALL_IC TRIG V(ic_ratio)=0.9 FALL=1 TARG V(ic_ratio)=0.1 FALL=1
.meas TRAN VCE_PEAK MAX V(vce)
.meas TRAN IB_REVERSE_PEAK MIN V(ib)
.meas TRAN IC_AT_COMMAND_OFF FIND V(ic) AT={T_OFF}
.meas TRAN E_OFF_WINDOW INTEG V(p_collector) FROM={T_OFF} TO={T_OFF+ENERGY_WINDOW}
.end
