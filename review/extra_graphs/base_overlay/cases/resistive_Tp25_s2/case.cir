* FJP5027 / resistive_Tp25_s2 / frozen model
* D:\2.github\QSPICElib\transistors\Si\transistor_common_cir_v1\bjt\03_resistive_switching_tran.qsch
V_BUS bus 0 {POL*VBUS}
R_LOAD bus c_feed {R_LOAD}
V_IC c_feed collector 0
X_DUT collector base 0 0 DUT_BJT
V_CMD cmd 0 PULSE(0 1 {T_DELAY} {T_EDGE} {T_EDGE} {TON} {TPER})
B_IBSRC 0 b_drive I={POL*(IB_OFF+(IB_ON-IB_OFF)*V(cmd))}
B_LIMIT b_drive 0 I={POL*(max(POL*V(b_drive)-VBE_MAX,0)+min(POL*V(b_drive)-VBE_MIN,0))/R_COMPLIANCE}
R_B b_drive b_feed {R_BASE}
V_IB b_feed base 0
B_VCE vce 0 V={POL*V(collector)}
B_VBE vbe 0 V={POL*V(base)}
B_IC ic 0 V={POL*I(V_IC)}
B_IB ib 0 V={POL*I(V_IB)}
B_CF ic_ratio 0 V={V(ic)/IC_REFERENCE}
B_PC p_collector 0 V={V(collector)*I(V_IC)}
B_PB p_base 0 V={V(base)*I(V_IB)}
B_PT p_total 0 V={V(p_collector)+V(p_base)}
.temp 25
.param VBUS=400
.param R_LOAD=200
.param IB_ON=0.4
.param IB_OFF=-0.8
.param R_BASE=1
.param VBE_MAX=3
.param VBE_MIN=-5
.param R_COMPLIANCE=1m
.param IC_REFERENCE=2
.param FSW=5000
.param DUTY=0.5
.param T_DELAY=5e-06
.param T_EDGE=5e-09
.param N_CYCLES=2
.param T_MAX=5e-10
.param TPER={1/FSW}
.param TON={DUTY*TPER-T_EDGE}
.param T_STOP={T_DELAY+N_CYCLES*TPER}
.param T_AVG0={T_DELAY+(N_CYCLES-1)*TPER}
.options reltol=1e-5 abstol=1e-12 vntol=1e-8
.tran 0 {T_STOP} 0 {T_MAX}
.param POL=1
* FJP5027_CANDIDATE_V1: independently constructed STARTING model, not vendor SPICE.
* User-supplied Fairchild Rev.A December 2003 is the reference.
* NOT YET CALIBRATED OR VALIDATED IN QSPICE. Compare every curve in the report.
* DC seed: BF/IKF/VAF approximate mid-current gain and its high-current rolloff.
* CJC chosen to give approximately 60 pF at VCB=10V, f=1MHz, 25 C.
* TF is an initial estimate from fT=15MHz; TR/CJE/RB and dynamic accuracy UNVALIDATED.
* XTB/temperature and high-injection/saturation behavior are calibration targets.
* No avalanche, secondary breakdown, SOA, self-heating or thermal memory model.
* Voltage rating is documentation, NOT an implemented breakdown mechanism.
.model FJP5027_CANDIDATE_V1 NPN(
+ IS=10f NF=1 BF=30 IKF=0.8 VAF=50 ISE=1p NE=1.5
+ BR=2 NR=1 IKR=0.02 VAR=20 ISC=1p NC=1.5
+ RB=2 RBM=0.3 IRB=0.01 RC=0.2 RE=0.02
+ CJE=2n VJE=0.75 MJE=0.33 CJC=144.46p VJC=0.75 MJC=0.33
+ TF=10n TR=300n XTB=1.1 EG=1.11 XTI=3 TNOM=25)

.subckt DUT_BJT C B E K
Q_CORE C B E FJP5027_CANDIDATE_V1
R_K K E 1u
.ends DUT_BJT
.meas TRAN T_STORAGE_CMD TRIG V(cmd)=0.9 FALL=1 TARG V(ic_ratio)=0.9 FALL=1
.meas TRAN T_STORAGE_IB TRIG V(ib)=0 FALL=1 TARG V(ic_ratio)=0.9 FALL=1
.meas TRAN T_FALL_IC TRIG V(ic_ratio)=0.9 FALL=1 TARG V(ic_ratio)=0.1 FALL=1
.meas TRAN VCE_PEAK MAX V(vce)
.meas TRAN IB_REVERSE_PEAK MIN V(ib)
.meas TRAN TON_IB TRIG V(ib)={0.1*IB_ON} RISE=1 TARG V(ic_ratio)=0.9 RISE=1
.meas TRAN IC_ON FIND V(ic) AT={T_DELAY+T_EDGE+0.8*TON}
.meas TRAN IB_ON_ACTUAL FIND V(ib) AT={T_DELAY+T_EDGE+0.8*TON}
.meas TRAN P_COLLECTOR_AVG AVG V(p_collector) FROM={T_AVG0} TO={T_STOP}
.meas TRAN P_BASE_AVG AVG V(p_base) FROM={T_AVG0} TO={T_STOP}
.meas TRAN P_TOTAL_AVG AVG V(p_total) FROM={T_AVG0} TO={T_STOP}
.end
