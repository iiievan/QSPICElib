* BAS316 DC table limits at TJ=25C.
.temp 25
.lib ../BAS316.txt
I_1M 0 a_1M 1m
D_1M a_1M 0 BAS316
I_10M 0 a_10M 10m
D_10M a_10M 0 BAS316
I_50M 0 a_50M 50m
D_50M a_50M 0 BAS316
I_150M 0 a_150M 150m
D_150M a_150M 0 BAS316
V_R25 r25 0 -25
D_R25 r25 0 BAS316
B_R25 ir25 0 V={abs(I(V_R25))}
V_R75 r75 0 -75
D_R75 r75 0 BAS316
B_R75 ir75 0 V={abs(I(V_R75))}
.options reltol=1e-5 abstol=1e-12 vntol=1e-8 gmin=1e-12
.tran 0 20u 0 50n
.meas TRAN VF_1M_MAX AVG V(a_1M) FROM=15u TO=20u
.meas TRAN VF_1M_TYP AVG V(a_1M) FROM=15u TO=20u
.meas TRAN VF_10M_MAX AVG V(a_10M) FROM=15u TO=20u
.meas TRAN VF_10M_TYP AVG V(a_10M) FROM=15u TO=20u
.meas TRAN VF_50M_MAX AVG V(a_50M) FROM=15u TO=20u
.meas TRAN VF_50M_TYP AVG V(a_50M) FROM=15u TO=20u
.meas TRAN VF_150M_MAX AVG V(a_150M) FROM=15u TO=20u
.meas TRAN VF_150M_TYP AVG V(a_150M) FROM=15u TO=20u
.meas TRAN IR_25_MAX AVG V(ir25) FROM=15u TO=20u
.meas TRAN IR_75_MAX AVG V(ir75) FROM=15u TO=20u
.end
