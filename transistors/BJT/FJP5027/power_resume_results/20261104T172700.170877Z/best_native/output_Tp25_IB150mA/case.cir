* FJP5027 / output_Tp25_IB150mA / frozen model
* D:\2.github\QSPICElib\transistors\Si\transistor_common_cir_v1\bjt\01_output_gummel_leakage_dc.qsch
V_SCAN scan 0 0
E_COUT cout_drive 0 scan 0 {POL*VCE_SWEEP}
R_COUT cout_drive cout_feed {R_COLLECTOR}
V_ICOUT cout_feed c_out 0
I_BOUT 0 b_out {POL*IB_TEST}
X_OUT c_out b_out 0 0 DUT_BJT
B_VCO vce_out 0 V={POL*V(c_out)}
B_ICO ic_out 0 V={POL*I(V_ICOUT)}
.temp 25
.param VCE_SWEEP=8
.param R_COLLECTOR=0.001
.param IB_TEST=0.15
.param IC_SAT_REF=5m
.param VCE_GUMMEL=5
.param VBE_START=0
.param VBE_STOP=0.9
.param VBLOCK_SCAN=20
.param IB_FLOOR=1p
.param SCAN_STEP=0.00025
.options reltol=1e-5 abstol=1e-13 vntol=1e-8
.dc V_SCAN 0 1 {SCAN_STEP}
.param POL=1
* Independent MEXTRAM 504 starting/fitted candidate. Not vendor SPICE.
* Domain of this extraction: isothermal DC at 25 C. Read the native report.
* Charge/transit/avalanche/thermal parameters are NOT extracted here.
* Self-heating is disabled by RTH=0; no transient thermal impedance is claimed.
.model FJP5027_MEXTRAM_DC25_CANDIDATE_V3 NPN(
+ LEVEL=504 TREF=25 IS=2.56212315717401e-14 BF=35.167556219634 VEF=618.404813872095
+ VER=42.0423371846927 IK=1 IBF=4.8783379259058e-12 MLF=1.50881604259697 BRI=6.35493387280118
+ IBR=9.19790477411798e-11 RE=0.001 RBC=0.0168490495318386 RBV=0.03 RCC=0.00103037374248808
+ RCV=0.260772065945659 SCRCV=6.65428944373425 IHC=3.80485836330227 AXI=0.334508317760624 CJE=2e-09
+ CJC=1.4446e-10 PE=0.33 PC=0.33 VDE=0.75 VDC=0.75
+ TAUE=5e-09 TAUB=5e-09 VGB=1.11 VGC=1.11 VGJ=1.11
+ EXAVL=0 RTH=0)

.subckt DUT_BJT C B E K
Q_CORE C B E FJP5027_MEXTRAM_DC25_CANDIDATE_V3
R_K K E 1u
.ends DUT_BJT
.meas DC O00 FIND V(ic_out) WHEN V(vce_out)=0.052202416607192 CROSS=1
.meas DC O01 FIND V(ic_out) WHEN V(vce_out)=0.123980125439693 CROSS=1
.meas DC O02 FIND V(ic_out) WHEN V(vce_out)=0.189233644038456 CROSS=1
.meas DC O03 FIND V(ic_out) WHEN V(vce_out)=0.261011352870956 CROSS=1
.meas DC O04 FIND V(ic_out) WHEN V(vce_out)=0.371941670702488 CROSS=1
.meas DC O05 FIND V(ic_out) WHEN V(vce_out)=0.450244399501683 CROSS=1
.meas DC O06 FIND V(ic_out) WHEN V(vce_out)=0.548123847666871 CROSS=1
.meas DC O07 FIND V(ic_out) WHEN V(vce_out)=0.678630055131441 CROSS=1
.meas DC O08 FIND V(ic_out) WHEN V(vce_out)=0.84828721212913 CROSS=1
.meas DC O09 FIND V(ic_out) WHEN V(vce_out)=1.02447021882647 CROSS=1
.meas DC O10 FIND V(ic_out) WHEN V(vce_out)=1.278955954323 CROSS=1
.meas DC O11 FIND V(ic_out) WHEN V(vce_out)=1.53344168981954 CROSS=1
.meas DC O12 FIND V(ic_out) WHEN V(vce_out)=1.85318094391483 CROSS=1
.meas DC O13 FIND V(ic_out) WHEN V(vce_out)=2.18597023794352 CROSS=1
.meas DC O14 FIND V(ic_out) WHEN V(vce_out)=2.53833625133819 CROSS=1
.meas DC O15 FIND V(ic_out) WHEN V(vce_out)=2.84502463576715 CROSS=1
.meas DC O16 FIND V(ic_out) WHEN V(vce_out)=3.21044068909521 CROSS=1
.meas DC O17 FIND V(ic_out) WHEN V(vce_out)=3.86296923721919 CROSS=1
.meas DC O18 FIND V(ic_out) WHEN V(vce_out)=4.3132138690461 CROSS=1
.meas DC O19 FIND V(ic_out) WHEN V(vce_out)=4.90048972830427 CROSS=1
.meas DC O20 FIND V(ic_out) WHEN V(vce_out)=5.28548084153242 CROSS=1
.meas DC O21 FIND V(ic_out) WHEN V(vce_out)=5.97063614895578 CROSS=1
.end
