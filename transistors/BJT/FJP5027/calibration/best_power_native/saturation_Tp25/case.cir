* FJP5027 / saturation_Tp25 / frozen model
* D:\2.github\QSPICElib\transistors\Si\transistor_common_cir_v1\bjt\05_forced_beta_saturation_dc.qsch
V_SCAN scan 0 0
B_IC_FORCE 0 c_feed I={POL*(IC_START+(IC_STOP-IC_START)*V(scan))}
V_IC c_feed collector 0
B_IB_FORCE 0 b_feed I={POL*(IC_START+(IC_STOP-IC_START)*V(scan))/BETA_FORCED}
V_IB b_feed base 0
X_DUT collector base 0 0 DUT_BJT
B_IC ic 0 V={POL*I(V_IC)}
B_IB ib 0 V={POL*I(V_IB)}
B_VCE vce 0 V={POL*V(collector)}
B_VBE vbe 0 V={POL*V(base)}
.temp 25
.param IC_START=0.1
.param IC_STOP=3
.param BETA_FORCED=5
.param IC_TEST=1.5
.param SCAN_STEP=0.002
.options reltol=1e-5 abstol=1e-12 vntol=1e-8
.dc V_SCAN 0 1 {SCAN_STEP}
.param POL=1
* Independent MEXTRAM 504 starting/fitted candidate. Not vendor SPICE.
* Domain of this extraction: isothermal DC at 25 C. Read the native report.
* Charge/transit/avalanche/thermal parameters are NOT extracted here.
* Self-heating is disabled by RTH=0; no transient thermal impedance is claimed.
.model FJP5027_MEXTRAM_DC25_CANDIDATE_V3 NPN(
+ LEVEL=504 TREF=25 IS=2.56212315717401e-14 BF=35.167556219634 VEF=618.404813872095
+ VER=42.0423371846927 IK=1 IBF=4.8783379259058e-12 MLF=1.50881604259697 BRI=6.35493387280118
+ IBR=9.19790477411798e-11 RE=0.001 RBC=0.0168490495318386 RBV=0.03 RCC=0.00103037374248808
+ RCV=0.260772065945659 SCRCV=6.65428944373425 IHC=3.80485836330227 AXI=0.334508317760624 CJE=2e-09
+ CJC=1.4446e-10 PE=0.33 PC=0.33 VDE=0.75 VDC=0.75
+ TAUE=5e-09 TAUB=5e-09 VGB=1.11 VGC=1.11 VGJ=1.11
+ EXAVL=0 RTH=0)

.subckt DUT_BJT C B E K
Q_CORE C B E FJP5027_MEXTRAM_DC25_CANDIDATE_V3
R_K K E 1u
.ends DUT_BJT
.meas DC C00 FIND V(vce) WHEN V(ic)=0.113185197126693 CROSS=1
.meas DC C01 FIND V(vce) WHEN V(ic)=0.150545976528241 CROSS=1
.meas DC C02 FIND V(vce) WHEN V(ic)=0.177577843623775 CROSS=1
.meas DC C03 FIND V(vce) WHEN V(ic)=0.196516324358389 CROSS=1
.meas DC C04 FIND V(vce) WHEN V(ic)=0.230934131075407 CROSS=1
.meas DC C05 FIND V(vce) WHEN V(ic)=0.258456799992556 CROSS=1
.meas DC C06 FIND V(vce) WHEN V(ic)=0.289259475295001 CROSS=1
.meas DC C07 FIND V(vce) WHEN V(ic)=0.334855459434478 CROSS=1
.meas DC C08 FIND V(vce) WHEN V(ic)=0.374763444894218 CROSS=1
.meas DC C09 FIND V(vce) WHEN V(ic)=0.419427453380876 CROSS=1
.meas DC C10 FIND V(vce) WHEN V(ic)=0.467656052203813 CROSS=1
.meas DC C11 FIND V(vce) WHEN V(ic)=0.521430549607961 CROSS=1
.meas DC C12 FIND V(vce) WHEN V(ic)=0.592401595909312 CROSS=1
.meas DC C13 FIND V(vce) WHEN V(ic)=0.667999149120067 CROSS=1
.meas DC C14 FIND V(vce) WHEN V(ic)=0.815014781951604 CROSS=1
.meas DC C15 FIND V(vce) WHEN V(ic)=0.932921462533671 CROSS=1
.meas DC C16 FIND V(vce) WHEN V(ic)=1.00564580384812 CROSS=1
.meas DC C17 FIND V(vce) WHEN V(ic)=1.07593179498216 CROSS=1
.meas DC C18 FIND V(vce) WHEN V(ic)=1.18621843914339 CROSS=1
.meas DC C19 FIND V(vce) WHEN V(ic)=1.26437075170342 CROSS=1
.meas DC C20 FIND V(vce) WHEN V(ic)=1.38875052821862 CROSS=1
.meas DC C21 FIND V(vce) WHEN V(ic)=1.49139974914139 CROSS=1
.meas DC C22 FIND V(vce) WHEN V(ic)=1.66289174964222 CROSS=1
.meas DC C23 FIND V(vce) WHEN V(ic)=1.83334289732563 CROSS=1
.meas DC C24 FIND V(vce) WHEN V(ic)=2.13832316765863 CROSS=1
.meas DC C25 FIND V(vce) WHEN V(ic)=2.33987798896636 CROSS=1
.meas DC C26 FIND V(vce) WHEN V(ic)=2.57005849650213 CROSS=1
.meas DC C27 FIND V(vce) WHEN V(ic)=2.99759288528353 CROSS=1
.meas DC B00 FIND V(vbe) WHEN V(ic)=0.113610849137292 CROSS=1
.meas DC B01 FIND V(vbe) WHEN V(ic)=0.13053577063326 CROSS=1
.meas DC B02 FIND V(vbe) WHEN V(ic)=0.15397462754824 CROSS=1
.meas DC B03 FIND V(vbe) WHEN V(ic)=0.169121553193 CROSS=1
.meas DC B04 FIND V(vbe) WHEN V(ic)=0.191420556056886 CROSS=1
.meas DC B05 FIND V(vbe) WHEN V(ic)=0.219113118309696 CROSS=1
.meas DC B06 FIND V(vbe) WHEN V(ic)=0.251755003783564 CROSS=1
.meas DC B07 FIND V(vbe) WHEN V(ic)=0.290347284305097 CROSS=1
.meas DC B08 FIND V(vbe) WHEN V(ic)=0.324950797175671 CROSS=1
.meas DC B09 FIND V(vbe) WHEN V(ic)=0.386186495204917 CROSS=1
.meas DC B10 FIND V(vbe) WHEN V(ic)=0.432212099987991 CROSS=1
.meas DC B11 FIND V(vbe) WHEN V(ic)=0.481910533757998 CROSS=1
.meas DC B12 FIND V(vbe) WHEN V(ic)=0.549561499584931 CROSS=1
.meas DC B13 FIND V(vbe) WHEN V(ic)=0.624361104805507 CROSS=1
.meas DC B14 FIND V(vbe) WHEN V(ic)=0.673032457719411 CROSS=1
.meas DC B15 FIND V(vbe) WHEN V(ic)=0.747610826337799 CROSS=1
.meas DC B16 FIND V(vbe) WHEN V(ic)=0.852561000533041 CROSS=1
.meas DC B17 FIND V(vbe) WHEN V(ic)=0.925944737116429 CROSS=1
.meas DC B18 FIND V(vbe) WHEN V(ic)=1.00564589983569 CROSS=1
.meas DC B19 FIND V(vbe) WHEN V(ic)=1.13397838568477 CROSS=1
.meas DC B20 FIND V(vbe) WHEN V(ic)=1.24553109124564 CROSS=1
.meas DC B21 FIND V(vbe) WHEN V(ic)=1.36805755633759 CROSS=1
.meas DC B22 FIND V(vbe) WHEN V(ic)=1.55426085698795 CROSS=1
.meas DC B23 FIND V(vbe) WHEN V(ic)=1.70715795443982 CROSS=1
.meas DC B24 FIND V(vbe) WHEN V(ic)=1.91780068721272 CROSS=1
.meas DC B25 FIND V(vbe) WHEN V(ic)=2.08287635372675 CROSS=1
.meas DC B26 FIND V(vbe) WHEN V(ic)=2.40216672462956 CROSS=1
.meas DC B27 FIND V(vbe) WHEN V(ic)=2.99759174081857 CROSS=1
.meas DC CHECK_VCE_15 FIND V(vce) WHEN V(ic)=1.5 CROSS=1
.meas DC CHECK_VBE_15 FIND V(vbe) WHEN V(ic)=1.5 CROSS=1
.meas DC CHECK_IB_15 FIND V(ib) WHEN V(ic)=1.5 CROSS=1
.end
