* FJP5027 / saturation_Tp25 / frozen model
* D:\2.github\QSPICElib\transistors\Si\transistor_common_cir_v1\bjt\05_forced_beta_saturation_dc.qsch
V_SCAN scan 0 0
B_IC_FORCE 0 c_feed I={POL*(IC_START+(IC_STOP-IC_START)*V(scan))}
V_IC c_feed collector 0
B_IB_FORCE 0 b_feed I={POL*(IC_START+(IC_STOP-IC_START)*V(scan))/BETA_FORCED}
V_IB b_feed base 0
X_DUT collector base 0 0 DUT_BJT
B_IC ic 0 V={POL*I(V_IC)}
B_IB ib 0 V={POL*I(V_IB)}
B_VCE vce 0 V={POL*V(collector)}
B_VBE vbe 0 V={POL*V(base)}
.temp 25
.param IC_START=0.1
.param IC_STOP=3
.param BETA_FORCED=5
.param IC_TEST=1.5
.param SCAN_STEP=0.0005
.options reltol=1e-5 abstol=1e-12 vntol=1e-8
.dc V_SCAN 0 1 {SCAN_STEP}
.param POL=1
* Independent MEXTRAM 504 starting/fitted candidate. Not vendor SPICE.
* Fit domain: isothermal DC at -25/25/75/125 C. Read the temperature report.
* Charge/transit/avalanche/thermal parameters are NOT extracted here.
* Self-heating is disabled by RTH=0; no transient thermal impedance is claimed.
.model FJP5027_MEXTRAM_DC25_CANDIDATE_V3 NPN(
+ AQBO=0.30919565803498 AE=0 AB=1.58335072317239 AEPI=0.238165357427909 AEX=0.62
+ AC=2 DAIS=0 DVGBF=0.0432789381710334 DVGBR=0.0215938761594345 LEVEL=504
+ TREF=25 IS=3.63204984302532e-14 BF=40.9619289016096 VEF=663.162781836839 VER=42.0423371846927
+ IK=0.962576579339957 IBF=3.27024409031111e-12 MLF=1.44266093324571 BRI=5.8940327923761 IBR=9.19939309011252e-11
+ RE=0.001 RBC=0.016336904900516 RBV=0.029999112518231 RCC=0.00103037374248808 RCV=0.204827722056095
+ SCRCV=4.42838000655518 IHC=2.06114708469111 AXI=0.347586723902527 CJE=2e-09 CJC=9.66455197629649e-11
+ PE=0.33 PC=0.33 VDE=0.75 VDC=0.75 TAUE=5e-09
+ TAUB=5e-09 VGB=1.23820435541847 VGC=1.11 VGJ=1.00307174903623 EXAVL=0
+ RTH=0)

.subckt DUT_BJT C B E K
Q_CORE C B E FJP5027_MEXTRAM_DC25_CANDIDATE_V3
R_K K E 1u
.ends DUT_BJT
.meas DC C00 FIND V(vce) WHEN V(ic)=0.113185197126693 CROSS=1
.meas DC C01 FIND V(vce) WHEN V(ic)=0.121551316620267 CROSS=1
.meas DC C02 FIND V(vce) WHEN V(ic)=0.123853847462896 CROSS=1
.meas DC C03 FIND V(vce) WHEN V(ic)=0.147193687511917 CROSS=1
.meas DC C04 FIND V(vce) WHEN V(ic)=0.150545976528241 CROSS=1
.meas DC C05 FIND V(vce) WHEN V(ic)=0.161067922161199 CROSS=1
.meas DC C06 FIND V(vce) WHEN V(ic)=0.164736113801841 CROSS=1
.meas DC C07 FIND V(vce) WHEN V(ic)=0.172973225806127 CROSS=1
.meas DC C08 FIND V(vce) WHEN V(ic)=0.177577843623775 CROSS=1
.meas DC C09 FIND V(vce) WHEN V(ic)=0.181622122048923 CROSS=1
.meas DC C10 FIND V(vce) WHEN V(ic)=0.186456977011985 CROSS=1
.meas DC C11 FIND V(vce) WHEN V(ic)=0.191420537786047 CROSS=1
.meas DC C12 FIND V(vce) WHEN V(ic)=0.196516324358389 CROSS=1
.meas DC C13 FIND V(vce) WHEN V(ic)=0.201747669061492 CROSS=1
.meas DC C14 FIND V(vce) WHEN V(ic)=0.212631847228553 CROSS=1
.meas DC C15 FIND V(vce) WHEN V(ic)=0.219113097395638 CROSS=1
.meas DC C16 FIND V(vce) WHEN V(ic)=0.230934131075407 CROSS=1
.meas DC C17 FIND V(vce) WHEN V(ic)=0.237973254777368 CROSS=1
.meas DC C18 FIND V(vce) WHEN V(ic)=0.244308199876327 CROSS=1
.meas DC C19 FIND V(vce) WHEN V(ic)=0.251754979753881 CROSS=1
.meas DC C20 FIND V(vce) WHEN V(ic)=0.258456799992556 CROSS=1
.meas DC C21 FIND V(vce) WHEN V(ic)=0.266334717496802 CROSS=1
.meas DC C22 FIND V(vce) WHEN V(ic)=0.273424786790651 CROSS=1
.meas DC C23 FIND V(vce) WHEN V(ic)=0.281758937465018 CROSS=1
.meas DC C24 FIND V(vce) WHEN V(ic)=0.289259475295001 CROSS=1
.meas DC C25 FIND V(vce) WHEN V(ic)=0.298076418979696 CROSS=1
.meas DC C26 FIND V(vce) WHEN V(ic)=0.307162112705715 CROSS=1
.meas DC C27 FIND V(vce) WHEN V(ic)=0.315338893421226 CROSS=1
.meas DC C28 FIND V(vce) WHEN V(ic)=0.334855459434478 CROSS=1
.meas DC C29 FIND V(vce) WHEN V(ic)=0.343769448334569 CROSS=1
.meas DC C30 FIND V(vce) WHEN V(ic)=0.354247915335152 CROSS=1
.meas DC C31 FIND V(vce) WHEN V(ic)=0.365045603200751 CROSS=1
.meas DC C32 FIND V(vce) WHEN V(ic)=0.374763444894218 CROSS=1
.meas DC C33 FIND V(vce) WHEN V(ic)=0.386186458343926 CROSS=1
.meas DC C34 FIND V(vce) WHEN V(ic)=0.396466899370204 CROSS=1
.meas DC C35 FIND V(vce) WHEN V(ic)=0.408551642042947 CROSS=1
.meas DC C36 FIND V(vce) WHEN V(ic)=0.419427453380876 CROSS=1
.meas DC C37 FIND V(vce) WHEN V(ic)=0.430592783252293 CROSS=1
.meas DC C38 FIND V(vce) WHEN V(ic)=0.443717720014 CROSS=1
.meas DC C39 FIND V(vce) WHEN V(ic)=0.455529666689914 CROSS=1
.meas DC C40 FIND V(vce) WHEN V(ic)=0.467656052203813 CROSS=1
.meas DC C41 FIND V(vce) WHEN V(ic)=0.481910717748936 CROSS=1
.meas DC C42 FIND V(vce) WHEN V(ic)=0.49473937760147 CROSS=1
.meas DC C43 FIND V(vce) WHEN V(ic)=0.507909541611416 CROSS=1
.meas DC C44 FIND V(vce) WHEN V(ic)=0.521430549607961 CROSS=1
.meas DC C45 FIND V(vce) WHEN V(ic)=0.535311243502645 CROSS=1
.meas DC C46 FIND V(vce) WHEN V(ic)=0.547502785356389 CROSS=1
.meas DC C47 FIND V(vce) WHEN V(ic)=0.577040265965223 CROSS=1
.meas DC C48 FIND V(vce) WHEN V(ic)=0.592401595909312 CROSS=1
.meas DC C49 FIND V(vce) WHEN V(ic)=0.605893352225687 CROSS=1
.meas DC C50 FIND V(vce) WHEN V(ic)=0.622022480373994 CROSS=1
.meas DC C51 FIND V(vce) WHEN V(ic)=0.650677839651252 CROSS=1
.meas DC C52 FIND V(vce) WHEN V(ic)=0.667999149120067 CROSS=1
.meas DC C53 FIND V(vce) WHEN V(ic)=0.68321261546065 CROSS=1
.meas DC C54 FIND V(vce) WHEN V(ic)=0.747610754979333 CROSS=1
.meas DC C55 FIND V(vce) WHEN V(ic)=0.764637350105567 CROSS=1
.meas DC C56 FIND V(vce) WHEN V(ic)=0.779122148193527 CROSS=1
.meas DC C57 FIND V(vce) WHEN V(ic)=0.815014781951604 CROSS=1
.meas DC C58 FIND V(vce) WHEN V(ic)=0.830453501373331 CROSS=1
.meas DC C59 FIND V(vce) WHEN V(ic)=0.849366813474408 CROSS=1
.meas DC C60 FIND V(vce) WHEN V(ic)=0.915577791059296 CROSS=1
.meas DC C61 FIND V(vce) WHEN V(ic)=0.932921462533671 CROSS=1
.meas DC C62 FIND V(vce) WHEN V(ic)=0.95059412659443 CROSS=1
.meas DC C63 FIND V(vce) WHEN V(ic)=0.968601570234765 CROSS=1
.meas DC C64 FIND V(vce) WHEN V(ic)=0.986949664288335 CROSS=1
.meas DC C65 FIND V(vce) WHEN V(ic)=1.00564580384812 CROSS=1
.meas DC C66 FIND V(vce) WHEN V(ic)=1.02085710365615 CROSS=1
.meas DC C67 FIND V(vce) WHEN V(ic)=1.0401955639355 CROSS=1
.meas DC C68 FIND V(vce) WHEN V(ic)=1.05592946002641 CROSS=1
.meas DC C69 FIND V(vce) WHEN V(ic)=1.07593179498216 CROSS=1
.meas DC C70 FIND V(vce) WHEN V(ic)=1.10872736731477 CROSS=1
.meas DC C71 FIND V(vce) WHEN V(ic)=1.12973038534408 CROSS=1
.meas DC C72 FIND V(vce) WHEN V(ic)=1.16416524168385 CROSS=1
.meas DC C73 FIND V(vce) WHEN V(ic)=1.18621843914339 CROSS=1
.meas DC C74 FIND V(vce) WHEN V(ic)=1.20416106292463 CROSS=1
.meas DC C75 FIND V(vce) WHEN V(ic)=1.2223750850736 CROSS=1
.meas DC C76 FIND V(vce) WHEN V(ic)=1.24086520293 CROSS=1
.meas DC C77 FIND V(vce) WHEN V(ic)=1.26437075170342 CROSS=1
.meas DC C78 FIND V(vce) WHEN V(ic)=1.32261783969923 CROSS=1
.meas DC C79 FIND V(vce) WHEN V(ic)=1.3476726612469 CROSS=1
.meas DC C80 FIND V(vce) WHEN V(ic)=1.3680574257583 CROSS=1
.meas DC C81 FIND V(vce) WHEN V(ic)=1.38875052821862 CROSS=1
.meas DC C82 FIND V(vce) WHEN V(ic)=1.41505812487606 CROSS=1
.meas DC C83 FIND V(vce) WHEN V(ic)=1.43646215530201 CROSS=1
.meas DC C84 FIND V(vce) WHEN V(ic)=1.4636735703312 CROSS=1
.meas DC C85 FIND V(vce) WHEN V(ic)=1.49139974914139 CROSS=1
.meas DC C86 FIND V(vce) WHEN V(ic)=1.51395923801626 CROSS=1
.meas DC C87 FIND V(vce) WHEN V(ic)=1.60163626694863 CROSS=1
.meas DC C88 FIND V(vce) WHEN V(ic)=1.63197663409641 CROSS=1
.meas DC C89 FIND V(vce) WHEN V(ic)=1.66289174964222 CROSS=1
.meas DC C90 FIND V(vce) WHEN V(ic)=1.72648915887678 CROSS=1
.meas DC C91 FIND V(vce) WHEN V(ic)=1.75919381933058 CROSS=1
.meas DC C92 FIND V(vce) WHEN V(ic)=1.79251885539777 CROSS=1
.meas DC C93 FIND V(vce) WHEN V(ic)=1.83334289732563 CROSS=1
.meas DC C94 FIND V(vce) WHEN V(ic)=1.93951712947716 CROSS=1
.meas DC C95 FIND V(vce) WHEN V(ic)=1.9836890099431 CROSS=1
.meas DC C96 FIND V(vce) WHEN V(ic)=2.09856922227002 CROSS=1
.meas DC C97 FIND V(vce) WHEN V(ic)=2.13832316765863 CROSS=1
.meas DC C98 FIND V(vce) WHEN V(ic)=2.22010348414562 CROSS=1
.meas DC C99 FIND V(vce) WHEN V(ic)=2.26215969641119 CROSS=1
.meas DC C100 FIND V(vce) WHEN V(ic)=2.29637690213521 CROSS=1
.meas DC C101 FIND V(vce) WHEN V(ic)=2.33987798896636 CROSS=1
.meas DC C102 FIND V(vce) WHEN V(ic)=2.37527075396194 CROSS=1
.meas DC C103 FIND V(vce) WHEN V(ic)=2.42026635517162 CROSS=1
.meas DC C104 FIND V(vce) WHEN V(ic)=2.53176208494512 CROSS=1
.meas DC C105 FIND V(vce) WHEN V(ic)=2.57005849650213 CROSS=1
.meas DC C106 FIND V(vce) WHEN V(ic)=2.59915986465071 CROSS=1
.meas DC C107 FIND V(vce) WHEN V(ic)=2.63847450187082 CROSS=1
.meas DC C108 FIND V(vce) WHEN V(ic)=2.66835056030844 CROSS=1
.meas DC C109 FIND V(vce) WHEN V(ic)=2.99759288528353 CROSS=1
.meas DC B00 FIND V(vbe) WHEN V(ic)=0.113610849137292 CROSS=1
.meas DC B01 FIND V(vbe) WHEN V(ic)=0.119740093303897 CROSS=1
.meas DC B02 FIND V(vbe) WHEN V(ic)=0.122008372605583 CROSS=1
.meas DC B03 FIND V(vbe) WHEN V(ic)=0.13053577063326 CROSS=1
.meas DC B04 FIND V(vbe) WHEN V(ic)=0.133008556301679 CROSS=1
.meas DC B05 FIND V(vbe) WHEN V(ic)=0.141240490477186 CROSS=1
.meas DC B06 FIND V(vbe) WHEN V(ic)=0.143916059472245 CROSS=1
.meas DC B07 FIND V(vbe) WHEN V(ic)=0.15397462754824 CROSS=1
.meas DC B08 FIND V(vbe) WHEN V(ic)=0.157481350298702 CROSS=1
.meas DC B09 FIND V(vbe) WHEN V(ic)=0.164736208144939 CROSS=1
.meas DC B10 FIND V(vbe) WHEN V(ic)=0.169121553193 CROSS=1
.meas DC B11 FIND V(vbe) WHEN V(ic)=0.182305055646488 CROSS=1
.meas DC B12 FIND V(vbe) WHEN V(ic)=0.186456994809059 CROSS=1
.meas DC B13 FIND V(vbe) WHEN V(ic)=0.191420556056886 CROSS=1
.meas DC B14 FIND V(vbe) WHEN V(ic)=0.196516249329506 CROSS=1
.meas DC B15 FIND V(vbe) WHEN V(ic)=0.213431485128099 CROSS=1
.meas DC B16 FIND V(vbe) WHEN V(ic)=0.219113118309696 CROSS=1
.meas DC B17 FIND V(vbe) WHEN V(ic)=0.230934153117767 CROSS=1
.meas DC B18 FIND V(vbe) WHEN V(ic)=0.23797316392045 CROSS=1
.meas DC B19 FIND V(vbe) WHEN V(ic)=0.244308106600761 CROSS=1
.meas DC B20 FIND V(vbe) WHEN V(ic)=0.251755003783564 CROSS=1
.meas DC B21 FIND V(vbe) WHEN V(ic)=0.266334742918101 CROSS=1
.meas DC B22 FIND V(vbe) WHEN V(ic)=0.273424682398527 CROSS=1
.meas DC B23 FIND V(vbe) WHEN V(ic)=0.290347284305097 CROSS=1
.meas DC B24 FIND V(vbe) WHEN V(ic)=0.298076447430699 CROSS=1
.meas DC B25 FIND V(vbe) WHEN V(ic)=0.316524476360155 CROSS=1
.meas DC B26 FIND V(vbe) WHEN V(ic)=0.324950797175671 CROSS=1
.meas DC B27 FIND V(vbe) WHEN V(ic)=0.343769481146912 CROSS=1
.meas DC B28 FIND V(vbe) WHEN V(ic)=0.35424778008519 CROSS=1
.meas DC B29 FIND V(vbe) WHEN V(ic)=0.374763480664897 CROSS=1
.meas DC B30 FIND V(vbe) WHEN V(ic)=0.386186495204917 CROSS=1
.meas DC B31 FIND V(vbe) WHEN V(ic)=0.39646693721245 CROSS=1
.meas DC B32 FIND V(vbe) WHEN V(ic)=0.408551486060112 CROSS=1
.meas DC B33 FIND V(vbe) WHEN V(ic)=0.432212099987991 CROSS=1
.meas DC B34 FIND V(vbe) WHEN V(ic)=0.443717762366275 CROSS=1
.meas DC B35 FIND V(vbe) WHEN V(ic)=0.46765609684097 CROSS=1
.meas DC B36 FIND V(vbe) WHEN V(ic)=0.481910533757998 CROSS=1
.meas DC B37 FIND V(vbe) WHEN V(ic)=0.494739660934884 CROSS=1
.meas DC B38 FIND V(vbe) WHEN V(ic)=0.50790983248728 CROSS=1
.meas DC B39 FIND V(vbe) WHEN V(ic)=0.535311294597401 CROSS=1
.meas DC B40 FIND V(vbe) WHEN V(ic)=0.549561499584931 CROSS=1
.meas DC B41 FIND V(vbe) WHEN V(ic)=0.577040321042959 CROSS=1
.meas DC B42 FIND V(vbe) WHEN V(ic)=0.592401369733547 CROSS=1
.meas DC B43 FIND V(vbe) WHEN V(ic)=0.624361104805507 CROSS=1
.meas DC B44 FIND V(vbe) WHEN V(ic)=0.640982463868544 CROSS=1
.meas DC B45 FIND V(vbe) WHEN V(ic)=0.655580633868929 CROSS=1
.meas DC B46 FIND V(vbe) WHEN V(ic)=0.673032457719411 CROSS=1
.meas DC B47 FIND V(vbe) WHEN V(ic)=0.709342196593272 CROSS=1
.meas DC B48 FIND V(vbe) WHEN V(ic)=0.728225175169992 CROSS=1
.meas DC B49 FIND V(vbe) WHEN V(ic)=0.747610826337799 CROSS=1
.meas DC B50 FIND V(vbe) WHEN V(ic)=0.767512531446081 CROSS=1
.meas DC B51 FIND V(vbe) WHEN V(ic)=0.808919419449159 CROSS=1
.meas DC B52 FIND V(vbe) WHEN V(ic)=0.830453976967625 CROSS=1
.meas DC B53 FIND V(vbe) WHEN V(ic)=0.852561000533041 CROSS=1
.meas DC B54 FIND V(vbe) WHEN V(ic)=0.875256522082062 CROSS=1
.meas DC B55 FIND V(vbe) WHEN V(ic)=0.898556207671028 CROSS=1
.meas DC B56 FIND V(vbe) WHEN V(ic)=0.925944737116429 CROSS=1
.meas DC B57 FIND V(vbe) WHEN V(ic)=0.950593763662669 CROSS=1
.meas DC B58 FIND V(vbe) WHEN V(ic)=0.979569363855002 CROSS=1
.meas DC B59 FIND V(vbe) WHEN V(ic)=1.00564589983569 CROSS=1
.meas DC B60 FIND V(vbe) WHEN V(ic)=1.03629858700669 CROSS=1
.meas DC B61 FIND V(vbe) WHEN V(ic)=1.0678855863754 CROSS=1
.meas DC B62 FIND V(vbe) WHEN V(ic)=1.10043642668677 CROSS=1
.meas DC B63 FIND V(vbe) WHEN V(ic)=1.13397838568477 CROSS=1
.meas DC B64 FIND V(vbe) WHEN V(ic)=1.17293655374255 CROSS=1
.meas DC B65 FIND V(vbe) WHEN V(ic)=1.20868951355713 CROSS=1
.meas DC B66 FIND V(vbe) WHEN V(ic)=1.24553109124564 CROSS=1
.meas DC B67 FIND V(vbe) WHEN V(ic)=1.28832168601049 CROSS=1
.meas DC B68 FIND V(vbe) WHEN V(ic)=1.3275917670061 CROSS=1
.meas DC B69 FIND V(vbe) WHEN V(ic)=1.36805755633759 CROSS=1
.meas DC B70 FIND V(vbe) WHEN V(ic)=1.41505758461443 CROSS=1
.meas DC B71 FIND V(vbe) WHEN V(ic)=1.45819077608723 CROSS=1
.meas DC B72 FIND V(vbe) WHEN V(ic)=1.50828735820225 CROSS=1
.meas DC B73 FIND V(vbe) WHEN V(ic)=1.55426085698795 CROSS=1
.meas DC B74 FIND V(vbe) WHEN V(ic)=1.60163718419333 CROSS=1
.meas DC B75 FIND V(vbe) WHEN V(ic)=1.65045604138405 CROSS=1
.meas DC B76 FIND V(vbe) WHEN V(ic)=1.70715795443982 CROSS=1
.meas DC B77 FIND V(vbe) WHEN V(ic)=1.81281613497127 CROSS=1
.meas DC B78 FIND V(vbe) WHEN V(ic)=1.86107403983665 CROSS=1
.meas DC B79 FIND V(vbe) WHEN V(ic)=1.91780068721272 CROSS=1
.meas DC B80 FIND V(vbe) WHEN V(ic)=1.96885332367644 CROSS=1
.meas DC B81 FIND V(vbe) WHEN V(ic)=2.02886708446989 CROSS=1
.meas DC B82 FIND V(vbe) WHEN V(ic)=2.08287635372675 CROSS=1
.meas DC B83 FIND V(vbe) WHEN V(ic)=2.13832337175877 CROSS=1
.meas DC B84 FIND V(vbe) WHEN V(ic)=2.19524641202472 CROSS=1
.meas DC B85 FIND V(vbe) WHEN V(ic)=2.29637712132137 CROSS=1
.meas DC B86 FIND V(vbe) WHEN V(ic)=2.40216672462956 CROSS=1
.meas DC B87 FIND V(vbe) WHEN V(ic)=2.44767182580605 CROSS=1
.meas DC B88 FIND V(vbe) WHEN V(ic)=2.49403656582071 CROSS=1
.meas DC B89 FIND V(vbe) WHEN V(ic)=2.99759174081857 CROSS=1
.meas DC CHECK_VCE_15 FIND V(vce) WHEN V(ic)=1.5 CROSS=1
.meas DC CHECK_VBE_15 FIND V(vbe) WHEN V(ic)=1.5 CROSS=1
.meas DC CHECK_IB_15 FIND V(ib) WHEN V(ic)=1.5 CROSS=1
.end
