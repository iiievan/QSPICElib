* FJP5027 / gain_Tp25 / frozen model
* D:\2.github\QSPICElib\transistors\Si\transistor_common_cir_v1\bjt\01_output_gummel_leakage_dc.qsch
V_SCAN scan 0 0
V_CG cg_feed 0 {POL*VCE_GUMMEL}
V_ICG cg_feed c_gummel 0
B_VBE_DRIVE bg_drive 0 V={POL*(VBE_START+(VBE_STOP-VBE_START)*V(scan))}
V_IBG bg_drive b_gummel 0
X_GUMMEL c_gummel b_gummel 0 0 DUT_BJT
B_ICG ic_gummel 0 V={POL*I(V_ICG)}
B_IBG ib_gummel 0 V={POL*I(V_IBG)}
B_VBG vbe 0 V={POL*V(b_gummel)}
.temp 25
.param VCE_SWEEP=10
.param R_COLLECTOR=1
.param IB_TEST=100u
.param IC_SAT_REF=5m
.param VCE_GUMMEL=5
.param VBE_START=0.4
.param VBE_STOP=2.2
.param VBLOCK_SCAN=20
.param IB_FLOOR=1p
.param SCAN_STEP=0.00025
.options reltol=1e-5 abstol=1e-13 vntol=1e-8
.dc V_SCAN 0 1 {SCAN_STEP}
.param POL=1
* Independent MEXTRAM 504 starting/fitted candidate. Not vendor SPICE.
* Fit domain: isothermal DC at -25/25/75/125 C. Read the temperature report.
* Charge/transit/avalanche/thermal parameters are NOT extracted here.
* Self-heating is disabled by RTH=0; no transient thermal impedance is claimed.
.model FJP5027_MEXTRAM_DC25_CANDIDATE_V3 NPN(
+ AQBO=0.30919565803498 AE=0 AB=1.58335072317239 AEPI=0.238165357427909 AEX=0.62
+ AC=2 DAIS=0 DVGBF=0.0432789381710334 DVGBR=0.0215938761594345 LEVEL=504
+ TREF=25 IS=3.63204984302532e-14 BF=40.9619289016096 VEF=663.162781836839 VER=42.0423371846927
+ IK=0.962576579339957 IBF=3.27024409031111e-12 MLF=1.44266093324571 BRI=5.8940327923761 IBR=9.19939309011252e-11
+ RE=0.001 RBC=0.016336904900516 RBV=0.029999112518231 RCC=0.00103037374248808 RCV=0.204827722056095
+ SCRCV=4.42838000655518 IHC=2.06114708469111 AXI=0.347586723902527 CJE=2e-09 CJC=9.66455197629649e-11
+ PE=0.33 PC=0.33 VDE=0.75 VDC=0.75 TAUE=5e-09
+ TAUB=5e-09 VGB=1.23820435541847 VGC=1.11 VGJ=1.00307174903623 EXAVL=0
+ RTH=0)

.subckt DUT_BJT C B E K
Q_CORE C B E FJP5027_MEXTRAM_DC25_CANDIDATE_V3
R_K K E 1u
.ends DUT_BJT
B_HFE_CALC hfe_calc 0 V={if(V(ib_gummel)>1e-10,V(ic_gummel)/max(V(ib_gummel),1e-12),0)}
.meas DC G00 FIND V(hfe_calc) WHEN V(ic_gummel)=0.0199863492165197 CROSS=1
.meas DC G01 FIND V(hfe_calc) WHEN V(ic_gummel)=0.0236637315056127 CROSS=1
.meas DC G02 FIND V(hfe_calc) WHEN V(ic_gummel)=0.0296402929278981 CROSS=1
.meas DC G03 FIND V(hfe_calc) WHEN V(ic_gummel)=0.0304864990525897 CROSS=1
.meas DC G04 FIND V(hfe_calc) WHEN V(ic_gummel)=0.0365045575326255 CROSS=1
.meas DC G05 FIND V(hfe_calc) WHEN V(ic_gummel)=0.037546732798518 CROSS=1
.meas DC G06 FIND V(hfe_calc) WHEN V(ic_gummel)=0.0444551325623153 CROSS=1
.meas DC G07 FIND V(hfe_calc) WHEN V(ic_gummel)=0.0454675405479245 CROSS=1
.meas DC G08 FIND V(hfe_calc) WHEN V(ic_gummel)=0.0520452703541809 CROSS=1
.meas DC G09 FIND V(hfe_calc) WHEN V(ic_gummel)=0.0535311202626845 CROSS=1
.meas DC G10 FIND V(hfe_calc) WHEN V(ic_gummel)=0.0575958409085723 CROSS=1
.meas DC G11 FIND V(hfe_calc) WHEN V(ic_gummel)=0.0592401550674152 CROSS=1
.meas DC G12 FIND V(hfe_calc) WHEN V(ic_gummel)=0.0651900258032171 CROSS=1
.meas DC G13 FIND V(hfe_calc) WHEN V(ic_gummel)=0.0670510517315569 CROSS=1
.meas DC G14 FIND V(hfe_calc) WHEN V(ic_gummel)=0.0717373777113132 CROSS=1
.meas DC G15 FIND V(hfe_calc) WHEN V(ic_gummel)=0.0737854211816087 CROSS=1
.meas DC G16 FIND V(hfe_calc) WHEN V(ic_gummel)=0.0789424250955069 CROSS=1
.meas DC G17 FIND V(hfe_calc) WHEN V(ic_gummel)=0.0807403520367146 CROSS=1
.meas DC G18 FIND V(hfe_calc) WHEN V(ic_gummel)=0.0868711218444345 CROSS=1
.meas DC G19 FIND V(hfe_calc) WHEN V(ic_gummel)=0.0888494989722241 CROSS=1
.meas DC G20 FIND V(hfe_calc) WHEN V(ic_gummel)=0.0929427103531432 CROSS=1
.meas DC G21 FIND V(hfe_calc) WHEN V(ic_gummel)=0.0950593600343422 CROSS=1
.meas DC G22 FIND V(hfe_calc) WHEN V(ic_gummel)=0.102277399586297 CROSS=1
.meas DC G23 FIND V(hfe_calc) WHEN V(ic_gummel)=0.104606784476239 CROSS=1
.meas DC G24 FIND V(hfe_calc) WHEN V(ic_gummel)=0.111917952296729 CROSS=1
.meas DC G25 FIND V(hfe_calc) WHEN V(ic_gummel)=0.114466902387832 CROSS=1
.meas DC G26 FIND V(hfe_calc) WHEN V(ic_gummel)=0.120416097097616 CROSS=1
.meas DC G27 FIND V(hfe_calc) WHEN V(ic_gummel)=0.123158593858578 CROSS=1
.meas DC G28 FIND V(hfe_calc) WHEN V(ic_gummel)=0.138614684628951 CROSS=1
.meas DC G29 FIND V(hfe_calc) WHEN V(ic_gummel)=0.142572020522714 CROSS=1
.meas DC G30 FIND V(hfe_calc) WHEN V(ic_gummel)=0.189989054519206 CROSS=1
.meas DC G31 FIND V(hfe_calc) WHEN V(ic_gummel)=0.195413086661857 CROSS=1
.meas DC G32 FIND V(hfe_calc) WHEN V(ic_gummel)=0.21383219838782 CROSS=1
.meas DC G33 FIND V(hfe_calc) WHEN V(ic_gummel)=0.219936932790149 CROSS=1
.meas DC G34 FIND V(hfe_calc) WHEN V(ic_gummel)=0.233987781029575 CROSS=1
.meas DC G35 FIND V(hfe_calc) WHEN V(ic_gummel)=0.242026617036264 CROSS=1
.meas DC G36 FIND V(hfe_calc) WHEN V(ic_gummel)=0.248936279034972 CROSS=1
.meas DC G37 FIND V(hfe_calc) WHEN V(ic_gummel)=0.257488682559943 CROSS=1
.meas DC G38 FIND V(hfe_calc) WHEN V(ic_gummel)=0.264839394706379 CROSS=1
.meas DC G39 FIND V(hfe_calc) WHEN V(ic_gummel)=0.273938162397527 CROSS=1
.meas DC G40 FIND V(hfe_calc) WHEN V(ic_gummel)=0.283349525477248 CROSS=1
.meas DC G41 FIND V(hfe_calc) WHEN V(ic_gummel)=0.29308422340832 CROSS=1
.meas DC G42 FIND V(hfe_calc) WHEN V(ic_gummel)=0.303153364616294 CROSS=1
.meas DC G43 FIND V(hfe_calc) WHEN V(ic_gummel)=0.31180814527191 CROSS=1
.meas DC G44 FIND V(hfe_calc) WHEN V(ic_gummel)=0.322520561682552 CROSS=1
.meas DC G45 FIND V(hfe_calc) WHEN V(ic_gummel)=0.345062139304177 CROSS=1
.meas DC G46 FIND V(hfe_calc) WHEN V(ic_gummel)=0.35491338120616 CROSS=1
.meas DC G47 FIND V(hfe_calc) WHEN V(ic_gummel)=0.379718954809516 CROSS=1
.meas DC G48 FIND V(hfe_calc) WHEN V(ic_gummel)=0.390559620453507 CROSS=1
.meas DC G49 FIND V(hfe_calc) WHEN V(ic_gummel)=0.40397702793719 CROSS=1
.meas DC G50 FIND V(hfe_calc) WHEN V(ic_gummel)=0.417855979495119 CROSS=1
.meas DC G51 FIND V(hfe_calc) WHEN V(ic_gummel)=0.429785426007267 CROSS=1
.meas DC G52 FIND V(hfe_calc) WHEN V(ic_gummel)=0.444551045573106 CROSS=1
.meas DC G53 FIND V(hfe_calc) WHEN V(ic_gummel)=0.457242614391845 CROSS=1
.meas DC G54 FIND V(hfe_calc) WHEN V(ic_gummel)=0.470296517121807 CROSS=1
.meas DC G55 FIND V(hfe_calc) WHEN V(ic_gummel)=0.486453927389232 CROSS=1
.meas DC G56 FIND V(hfe_calc) WHEN V(ic_gummel)=0.500341789217669 CROSS=1
.meas DC G57 FIND V(hfe_calc) WHEN V(ic_gummel)=0.514625401339204 CROSS=1
.meas DC G58 FIND V(hfe_calc) WHEN V(ic_gummel)=0.529317535711642 CROSS=1
.meas DC G59 FIND V(hfe_calc) WHEN V(ic_gummel)=0.544429118505894 CROSS=1
.meas DC G60 FIND V(hfe_calc) WHEN V(ic_gummel)=0.556828582780719 CROSS=1
.meas DC G61 FIND V(hfe_calc) WHEN V(ic_gummel)=0.572724763483635 CROSS=1
.meas DC G62 FIND V(hfe_calc) WHEN V(ic_gummel)=0.585768665807617 CROSS=1
.meas DC G63 FIND V(hfe_calc) WHEN V(ic_gummel)=0.602491882203102 CROSS=1
.meas DC G64 FIND V(hfe_calc) WHEN V(ic_gummel)=0.616212853385724 CROSS=1
.meas DC G65 FIND V(hfe_calc) WHEN V(ic_gummel)=0.644601189771678 CROSS=1
.meas DC G66 FIND V(hfe_calc) WHEN V(ic_gummel)=0.663004026615941 CROSS=1
.meas DC G67 FIND V(hfe_calc) WHEN V(ic_gummel)=0.725497002135711 CROSS=1
.meas DC G68 FIND V(hfe_calc) WHEN V(ic_gummel)=0.737854803404911 CROSS=1
.meas DC G69 FIND V(hfe_calc) WHEN V(ic_gummel)=0.754658489551615 CROSS=1
.meas DC G70 FIND V(hfe_calc) WHEN V(ic_gummel)=0.771845962930277 CROSS=1
.meas DC G71 FIND V(hfe_calc) WHEN V(ic_gummel)=0.789424883891165 CROSS=1
.meas DC G72 FIND V(hfe_calc) WHEN V(ic_gummel)=0.807403011734328 CROSS=1
.meas DC G73 FIND V(hfe_calc) WHEN V(ic_gummel)=0.883507911982784 CROSS=1
.meas DC G74 FIND V(hfe_calc) WHEN V(ic_gummel)=0.903628658764643 CROSS=1
.meas DC G75 FIND V(hfe_calc) WHEN V(ic_gummel)=0.945257966222373 CROSS=1
.meas DC G76 FIND V(hfe_calc) WHEN V(ic_gummel)=0.966784990399454 CROSS=1
.meas DC G77 FIND V(hfe_calc) WHEN V(ic_gummel)=0.994385911285288 CROSS=1
.meas DC G78 FIND V(hfe_calc) WHEN V(ic_gummel)=1.0170332168082 CROSS=1
.meas DC G79 FIND V(hfe_calc) WHEN V(ic_gummel)=1.04606868346743 CROSS=1
.meas DC G80 FIND V(hfe_calc) WHEN V(ic_gummel)=1.06989154097783 CROSS=1
.meas DC G81 FIND V(hfe_calc) WHEN V(ic_gummel)=1.10043606956712 CROSS=1
.meas DC G82 FIND V(hfe_calc) WHEN V(ic_gummel)=1.1318526194698 CROSS=1
.meas DC G83 FIND V(hfe_calc) WHEN V(ic_gummel)=1.16416608618126 CROSS=1
.meas DC G84 FIND V(hfe_calc) WHEN V(ic_gummel)=1.19740036158739 CROSS=1
.meas DC G85 FIND V(hfe_calc) WHEN V(ic_gummel)=1.23158516273453 CROSS=1
.meas DC G86 FIND V(hfe_calc) WHEN V(ic_gummel)=1.43376811859414 CROSS=1
.meas DC G87 FIND V(hfe_calc) WHEN V(ic_gummel)=1.47470102591369 CROSS=1
.meas DC G88 FIND V(hfe_calc) WHEN V(ic_gummel)=1.52536555059123 CROSS=1
.meas DC G89 FIND V(hfe_calc) WHEN V(ic_gummel)=1.56891348969034 CROSS=1
.meas DC G90 FIND V(hfe_calc) WHEN V(ic_gummel)=1.67856784792713 CROSS=1
.meas DC G91 FIND V(hfe_calc) WHEN V(ic_gummel)=1.72648958733374 CROSS=1
.meas DC G92 FIND V(hfe_calc) WHEN V(ic_gummel)=1.78580450796234 CROSS=1
.meas DC G93 FIND V(hfe_calc) WHEN V(ic_gummel)=1.84715723978598 CROSS=1
.meas DC G94 FIND V(hfe_calc) WHEN V(ic_gummel)=1.89988934833491 CROSS=1
.meas DC G95 FIND V(hfe_calc) WHEN V(ic_gummel)=1.96516155543443 CROSS=1
.meas DC G96 FIND V(hfe_calc) WHEN V(ic_gummel)=2.02126531082788 CROSS=1
.meas DC G97 FIND V(hfe_calc) WHEN V(ic_gummel)=2.09070748549298 CROSS=1
.meas DC G98 FIND V(hfe_calc) WHEN V(ic_gummel)=2.1503954745242 CROSS=1
.meas DC G99 FIND V(hfe_calc) WHEN V(ic_gummel)=2.22427401849416 CROSS=1
.meas DC G100 FIND V(hfe_calc) WHEN V(ic_gummel)=2.28777522281831 CROSS=1
.meas DC G101 FIND V(hfe_calc) WHEN V(ic_gummel)=2.42026464568908 CROSS=1
.meas DC G102 FIND V(hfe_calc) WHEN V(ic_gummel)=2.50341475931413 CROSS=1
.meas DC G103 FIND V(hfe_calc) WHEN V(ic_gummel)=2.64839607046464 CROSS=1
.meas DC G104 FIND V(hfe_calc) WHEN V(ic_gummel)=2.70871373413302 CROSS=1
.meas DC G105 FIND V(hfe_calc) WHEN V(ic_gummel)=2.8655805083589 CROSS=1
.meas DC G106 FIND V(hfe_calc) WHEN V(ic_gummel)=2.93084458394241 CROSS=1
.meas DC G107 FIND V(hfe_calc) WHEN V(ic_gummel)=3.01451780011082 CROSS=1
.meas DC G108 FIND V(hfe_calc) WHEN V(ic_gummel)=3.08316953316583 CROSS=1
.meas DC G109 FIND V(hfe_calc) WHEN V(ic_gummel)=3.1533892351991 CROSS=1
.meas DC G110 FIND V(hfe_calc) WHEN V(ic_gummel)=3.3737856274341 CROSS=1
.meas DC G111 FIND V(hfe_calc) WHEN V(ic_gummel)=3.43124831589581 CROSS=1
.meas DC G112 FIND V(hfe_calc) WHEN V(ic_gummel)=3.50939557045075 CROSS=1
.meas DC G113 FIND V(hfe_calc) WHEN V(ic_gummel)=3.56916798240068 CROSS=1
.meas DC G114 FIND V(hfe_calc) WHEN V(ic_gummel)=3.65045638043875 CROSS=1
.meas DC G115 FIND V(hfe_calc) WHEN V(ic_gummel)=3.71263667113402 CROSS=1
.meas DC G116 FIND V(hfe_calc) WHEN V(ic_gummel)=3.77587070789977 CROSS=1
.meas DC G117 FIND V(hfe_calc) WHEN V(ic_gummel)=3.84018175374555 CROSS=1
.meas DC G118 FIND V(hfe_calc) WHEN V(ic_gummel)=3.90559374416135 CROSS=1
.meas DC G119 FIND V(hfe_calc) WHEN V(ic_gummel)=3.97211424705099 CROSS=1
.meas DC G120 FIND V(hfe_calc) WHEN V(ic_gummel)=4.01709525175124 CROSS=1
.meas DC G121 FIND V(hfe_calc) WHEN V(ic_gummel)=4.08551486060112 CROSS=1
.meas DC G122 FIND V(hfe_calc) WHEN V(ic_gummel)=4.15510574875234 CROSS=1
.meas DC G123 FIND V(hfe_calc) WHEN V(ic_gummel)=4.20215296893456 CROSS=1
.meas DC G124 FIND V(hfe_calc) WHEN V(ic_gummel)=4.24973289299021 CROSS=1
.meas DC G125 FIND V(hfe_calc) WHEN V(ic_gummel)=4.2978577059601 CROSS=1
.meas DC G126 FIND V(hfe_calc) WHEN V(ic_gummel)=4.37105929185878 CROSS=1
.meas DC G127 FIND V(hfe_calc) WHEN V(ic_gummel)=4.42055169984271 CROSS=1
.meas DC G128 FIND V(hfe_calc) WHEN V(ic_gummel)=4.44551402000469 CROSS=1
.meas DC G129 FIND V(hfe_calc) WHEN V(ic_gummel)=4.49584946020018 CROSS=1
.meas DC G130 FIND V(hfe_calc) WHEN V(ic_gummel)=4.54675483595955 CROSS=1
.meas DC G131 FIND V(hfe_calc) WHEN V(ic_gummel)=4.5724232634678 CROSS=1
.meas DC G132 FIND V(hfe_calc) WHEN V(ic_gummel)=4.97532683558784 CROSS=1
.meas DC CHECK_GAIN_IC_MIN MIN V(ic_gummel)
.meas DC CHECK_GAIN_IC_MAX MAX V(ic_gummel)
.meas DC CHECK_GAIN_SCAN_END FIND V(scan) AT=1
.meas DC CHECK_GAIN_VBE_END FIND V(vbe) AT=1
.meas DC CHECK_HFE_02 FIND V(hfe_calc) WHEN V(ic_gummel)=0.2 CROSS=1
.meas DC CHECK_HFE_1 FIND V(hfe_calc) WHEN V(ic_gummel)=1 CROSS=1
.end
