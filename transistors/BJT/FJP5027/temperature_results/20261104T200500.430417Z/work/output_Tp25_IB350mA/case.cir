* FJP5027 / output_Tp25_IB350mA / frozen model
* D:\2.github\QSPICElib\transistors\Si\transistor_common_cir_v1\bjt\01_output_gummel_leakage_dc.qsch
V_SCAN scan 0 0
E_COUT cout_drive 0 scan 0 {POL*VCE_SWEEP}
R_COUT cout_drive cout_feed {R_COLLECTOR}
V_ICOUT cout_feed c_out 0
I_BOUT 0 b_out {POL*IB_TEST}
X_OUT c_out b_out 0 0 DUT_BJT
B_VCO vce_out 0 V={POL*V(c_out)}
B_ICO ic_out 0 V={POL*I(V_ICOUT)}
.temp 25
.param VCE_SWEEP=8
.param R_COLLECTOR=0.001
.param IB_TEST=0.35
.param IC_SAT_REF=5m
.param VCE_GUMMEL=5
.param VBE_START=0
.param VBE_STOP=0.9
.param VBLOCK_SCAN=20
.param IB_FLOOR=1p
.param SCAN_STEP=0.00025
.options reltol=1e-5 abstol=1e-13 vntol=1e-8
.dc V_SCAN 0 1 {SCAN_STEP}
.param POL=1
* Independent MEXTRAM 504 starting/fitted candidate. Not vendor SPICE.
* Fit domain: isothermal DC at -25/25/75/125 C. Read the temperature report.
* Charge/transit/avalanche/thermal parameters are NOT extracted here.
* Self-heating is disabled by RTH=0; no transient thermal impedance is claimed.
.model FJP5027_MEXTRAM_DC25_CANDIDATE_V3 NPN(
+ AQBO=0.30919565803498 AE=0 AB=1.58335072317239 AEPI=0.238165357427909 AEX=0.62
+ AC=2 DAIS=0 DVGBF=0.0432789381710334 DVGBR=0.0215938761594345 LEVEL=504
+ TREF=25 IS=3.63204984302532e-14 BF=40.9619289016096 VEF=663.162781836839 VER=42.0423371846927
+ IK=0.962576579339957 IBF=3.27024409031111e-12 MLF=1.44266093324571 BRI=5.8940327923761 IBR=9.19939309011252e-11
+ RE=0.001 RBC=0.016336904900516 RBV=0.029999112518231 RCC=0.00103037374248808 RCV=0.204827722056095
+ SCRCV=4.42838000655518 IHC=2.06114708469111 AXI=0.347586723902527 CJE=2e-09 CJC=9.66455197629649e-11
+ PE=0.33 PC=0.33 VDE=0.75 VDC=0.75 TAUE=5e-09
+ TAUB=5e-09 VGB=1.23820435541847 VGC=1.11 VGJ=1.00307174903623 EXAVL=0
+ RTH=0)

.subckt DUT_BJT C B E K
Q_CORE C B E FJP5027_MEXTRAM_DC25_CANDIDATE_V3
R_K K E 1u
.ends DUT_BJT
.meas DC O00 FIND V(ic_out) WHEN V(vce_out)=0.052202416607192 CROSS=1
.meas DC O01 FIND V(ic_out) WHEN V(vce_out)=0.0587274365738858 CROSS=1
.meas DC O02 FIND V(ic_out) WHEN V(vce_out)=0.0652524565405797 CROSS=1
.meas DC O03 FIND V(ic_out) WHEN V(vce_out)=0.0717783062402296 CROSS=1
.meas DC O04 FIND V(ic_out) WHEN V(vce_out)=0.0783033262069235 CROSS=1
.meas DC O05 FIND V(ic_out) WHEN V(vce_out)=0.0848283461736173 CROSS=1
.meas DC O06 FIND V(ic_out) WHEN V(vce_out)=0.0913541958732673 CROSS=1
.meas DC O07 FIND V(ic_out) WHEN V(vce_out)=0.0978792158399611 CROSS=1
.meas DC O08 FIND V(ic_out) WHEN V(vce_out)=0.104404235806655 CROSS=1
.meas DC O09 FIND V(ic_out) WHEN V(vce_out)=0.110930085506305 CROSS=1
.meas DC O10 FIND V(ic_out) WHEN V(vce_out)=0.117455105472999 CROSS=1
.meas DC O11 FIND V(ic_out) WHEN V(vce_out)=0.123980125439693 CROSS=1
.meas DC O12 FIND V(ic_out) WHEN V(vce_out)=0.130505975139343 CROSS=1
.meas DC O13 FIND V(ic_out) WHEN V(vce_out)=0.137030995106036 CROSS=1
.meas DC O14 FIND V(ic_out) WHEN V(vce_out)=0.14355601507273 CROSS=1
.meas DC O15 FIND V(ic_out) WHEN V(vce_out)=0.15008186477238 CROSS=1
.meas DC O16 FIND V(ic_out) WHEN V(vce_out)=0.156606884739074 CROSS=1
.meas DC O17 FIND V(ic_out) WHEN V(vce_out)=0.163131904705768 CROSS=1
.meas DC O18 FIND V(ic_out) WHEN V(vce_out)=0.169657754405418 CROSS=1
.meas DC O19 FIND V(ic_out) WHEN V(vce_out)=0.176182774372112 CROSS=1
.meas DC O20 FIND V(ic_out) WHEN V(vce_out)=0.182707794338806 CROSS=1
.meas DC O21 FIND V(ic_out) WHEN V(vce_out)=0.189233644038456 CROSS=1
.meas DC O22 FIND V(ic_out) WHEN V(vce_out)=0.195758664005149 CROSS=1
.meas DC O23 FIND V(ic_out) WHEN V(vce_out)=0.202283683971843 CROSS=1
.meas DC O24 FIND V(ic_out) WHEN V(vce_out)=0.208809533671493 CROSS=1
.meas DC O25 FIND V(ic_out) WHEN V(vce_out)=0.215334553638187 CROSS=1
.meas DC O26 FIND V(ic_out) WHEN V(vce_out)=0.221859573604881 CROSS=1
.meas DC O27 FIND V(ic_out) WHEN V(vce_out)=0.228384593571575 CROSS=1
.meas DC O28 FIND V(ic_out) WHEN V(vce_out)=0.234910443271225 CROSS=1
.meas DC O29 FIND V(ic_out) WHEN V(vce_out)=0.241435463237919 CROSS=1
.meas DC O30 FIND V(ic_out) WHEN V(vce_out)=0.247960483204612 CROSS=1
.meas DC O31 FIND V(ic_out) WHEN V(vce_out)=0.254486332904262 CROSS=1
.meas DC O32 FIND V(ic_out) WHEN V(vce_out)=0.261011352870956 CROSS=1
.meas DC O33 FIND V(ic_out) WHEN V(vce_out)=0.26753637283765 CROSS=1
.meas DC O34 FIND V(ic_out) WHEN V(vce_out)=0.2740622225373 CROSS=1
.meas DC O35 FIND V(ic_out) WHEN V(vce_out)=0.280587242503994 CROSS=1
.meas DC O36 FIND V(ic_out) WHEN V(vce_out)=0.287112262470688 CROSS=1
.meas DC O37 FIND V(ic_out) WHEN V(vce_out)=0.293638112170338 CROSS=1
.meas DC O38 FIND V(ic_out) WHEN V(vce_out)=0.300163132137031 CROSS=1
.meas DC O39 FIND V(ic_out) WHEN V(vce_out)=0.306688152103725 CROSS=1
.meas DC O40 FIND V(ic_out) WHEN V(vce_out)=0.313214001803375 CROSS=1
.meas DC O41 FIND V(ic_out) WHEN V(vce_out)=0.319739021770069 CROSS=1
.meas DC O42 FIND V(ic_out) WHEN V(vce_out)=0.326264041736763 CROSS=1
.meas DC O43 FIND V(ic_out) WHEN V(vce_out)=0.332789891436413 CROSS=1
.meas DC O44 FIND V(ic_out) WHEN V(vce_out)=0.345839931369801 CROSS=1
.meas DC O45 FIND V(ic_out) WHEN V(vce_out)=0.352365781069451 CROSS=1
.meas DC O46 FIND V(ic_out) WHEN V(vce_out)=0.358890801036144 CROSS=1
.meas DC O47 FIND V(ic_out) WHEN V(vce_out)=0.365415821002838 CROSS=1
.meas DC O48 FIND V(ic_out) WHEN V(vce_out)=0.371941670702488 CROSS=1
.meas DC O49 FIND V(ic_out) WHEN V(vce_out)=0.378466690669182 CROSS=1
.meas DC O50 FIND V(ic_out) WHEN V(vce_out)=0.384991710635876 CROSS=1
.meas DC O51 FIND V(ic_out) WHEN V(vce_out)=0.39151673060257 CROSS=1
.meas DC O52 FIND V(ic_out) WHEN V(vce_out)=0.404567600268914 CROSS=1
.meas DC O53 FIND V(ic_out) WHEN V(vce_out)=0.411092620235607 CROSS=1
.meas DC O54 FIND V(ic_out) WHEN V(vce_out)=0.417618469935257 CROSS=1
.meas DC O55 FIND V(ic_out) WHEN V(vce_out)=0.430668509868645 CROSS=1
.meas DC O56 FIND V(ic_out) WHEN V(vce_out)=0.437194359568295 CROSS=1
.meas DC O57 FIND V(ic_out) WHEN V(vce_out)=0.443719379534989 CROSS=1
.meas DC O58 FIND V(ic_out) WHEN V(vce_out)=0.502447048434102 CROSS=1
.meas DC O59 FIND V(ic_out) WHEN V(vce_out)=0.515497918100446 CROSS=1
.meas DC O60 FIND V(ic_out) WHEN V(vce_out)=0.52202293806714 CROSS=1
.meas DC O61 FIND V(ic_out) WHEN V(vce_out)=0.528547958033833 CROSS=1
.meas DC O62 FIND V(ic_out) WHEN V(vce_out)=0.535073807733483 CROSS=1
.meas DC O63 FIND V(ic_out) WHEN V(vce_out)=0.541598827700177 CROSS=1
.meas DC O64 FIND V(ic_out) WHEN V(vce_out)=0.548123847666871 CROSS=1
.meas DC O65 FIND V(ic_out) WHEN V(vce_out)=0.554648867633565 CROSS=1
.meas DC O66 FIND V(ic_out) WHEN V(vce_out)=0.561174717333215 CROSS=1
.meas DC O67 FIND V(ic_out) WHEN V(vce_out)=0.574224757266602 CROSS=1
.meas DC O68 FIND V(ic_out) WHEN V(vce_out)=0.580750606966252 CROSS=1
.meas DC O69 FIND V(ic_out) WHEN V(vce_out)=0.587275626932946 CROSS=1
.meas DC O70 FIND V(ic_out) WHEN V(vce_out)=0.59380064689964 CROSS=1
.meas DC O71 FIND V(ic_out) WHEN V(vce_out)=0.60032649659929 CROSS=1
.meas DC O72 FIND V(ic_out) WHEN V(vce_out)=0.606851516565984 CROSS=1
.meas DC O73 FIND V(ic_out) WHEN V(vce_out)=0.613376536532678 CROSS=1
.meas DC O74 FIND V(ic_out) WHEN V(vce_out)=0.619902386232328 CROSS=1
.meas DC O75 FIND V(ic_out) WHEN V(vce_out)=0.632952426165715 CROSS=1
.meas DC O76 FIND V(ic_out) WHEN V(vce_out)=0.639478275865365 CROSS=1
.meas DC O77 FIND V(ic_out) WHEN V(vce_out)=0.646003295832059 CROSS=1
.meas DC O78 FIND V(ic_out) WHEN V(vce_out)=0.652528315798753 CROSS=1
.meas DC O79 FIND V(ic_out) WHEN V(vce_out)=0.659054165498403 CROSS=1
.meas DC O80 FIND V(ic_out) WHEN V(vce_out)=0.665579185465097 CROSS=1
.meas DC O81 FIND V(ic_out) WHEN V(vce_out)=0.678630055131441 CROSS=1
.meas DC O82 FIND V(ic_out) WHEN V(vce_out)=0.691680095064828 CROSS=1
.meas DC O83 FIND V(ic_out) WHEN V(vce_out)=0.704730964731172 CROSS=1
.meas DC O84 FIND V(ic_out) WHEN V(vce_out)=0.711255984697866 CROSS=1
.meas DC O85 FIND V(ic_out) WHEN V(vce_out)=0.71778100466456 CROSS=1
.meas DC O86 FIND V(ic_out) WHEN V(vce_out)=0.72430685436421 CROSS=1
.meas DC O87 FIND V(ic_out) WHEN V(vce_out)=0.730831874330904 CROSS=1
.meas DC O88 FIND V(ic_out) WHEN V(vce_out)=0.737356894297598 CROSS=1
.meas DC O89 FIND V(ic_out) WHEN V(vce_out)=0.750407763963941 CROSS=1
.meas DC O90 FIND V(ic_out) WHEN V(vce_out)=0.756932783930635 CROSS=1
.meas DC O91 FIND V(ic_out) WHEN V(vce_out)=0.763458633630285 CROSS=1
.meas DC O92 FIND V(ic_out) WHEN V(vce_out)=0.776508673563673 CROSS=1
.meas DC O93 FIND V(ic_out) WHEN V(vce_out)=0.796084563196711 CROSS=1
.meas DC O94 FIND V(ic_out) WHEN V(vce_out)=0.80261041289636 CROSS=1
.meas DC O95 FIND V(ic_out) WHEN V(vce_out)=0.809135432863054 CROSS=1
.meas DC O96 FIND V(ic_out) WHEN V(vce_out)=0.822186302529398 CROSS=1
.meas DC O97 FIND V(ic_out) WHEN V(vce_out)=0.835236342462786 CROSS=1
.meas DC O98 FIND V(ic_out) WHEN V(vce_out)=0.841762192162436 CROSS=1
.meas DC O99 FIND V(ic_out) WHEN V(vce_out)=0.854812232095823 CROSS=1
.meas DC O100 FIND V(ic_out) WHEN V(vce_out)=0.867863101762167 CROSS=1
.meas DC O101 FIND V(ic_out) WHEN V(vce_out)=0.874388121728861 CROSS=1
.meas DC O102 FIND V(ic_out) WHEN V(vce_out)=0.887438991395205 CROSS=1
.meas DC O103 FIND V(ic_out) WHEN V(vce_out)=0.893964011361899 CROSS=1
.meas DC O104 FIND V(ic_out) WHEN V(vce_out)=0.907014881028243 CROSS=1
.meas DC O105 FIND V(ic_out) WHEN V(vce_out)=0.933115790627974 CROSS=1
.meas DC O106 FIND V(ic_out) WHEN V(vce_out)=0.952691680261012 CROSS=1
.meas DC O107 FIND V(ic_out) WHEN V(vce_out)=0.972267569894049 CROSS=1
.meas DC O108 FIND V(ic_out) WHEN V(vce_out)=0.991843459527087 CROSS=1
.meas DC O109 FIND V(ic_out) WHEN V(vce_out)=0.998368479493781 CROSS=1
.meas DC O110 FIND V(ic_out) WHEN V(vce_out)=1.01794436912682 CROSS=1
.meas DC O111 FIND V(ic_out) WHEN V(vce_out)=1.03752025875986 CROSS=1
.meas DC O112 FIND V(ic_out) WHEN V(vce_out)=1.06362116835959 CROSS=1
.meas DC O113 FIND V(ic_out) WHEN V(vce_out)=1.08319705799263 CROSS=1
.meas DC O114 FIND V(ic_out) WHEN V(vce_out)=1.10277294762566 CROSS=1
.meas DC O115 FIND V(ic_out) WHEN V(vce_out)=1.1223488372587 CROSS=1
.meas DC O116 FIND V(ic_out) WHEN V(vce_out)=1.14192472689174 CROSS=1
.meas DC O117 FIND V(ic_out) WHEN V(vce_out)=1.15497559655808 CROSS=1
.meas DC O118 FIND V(ic_out) WHEN V(vce_out)=1.16150061652478 CROSS=1
.meas DC O119 FIND V(ic_out) WHEN V(vce_out)=1.17455148619112 CROSS=1
.meas DC O120 FIND V(ic_out) WHEN V(vce_out)=1.18107650615781 CROSS=1
.meas DC O121 FIND V(ic_out) WHEN V(vce_out)=1.20065239579085 CROSS=1
.meas DC O122 FIND V(ic_out) WHEN V(vce_out)=1.20717741575755 CROSS=1
.meas DC O123 FIND V(ic_out) WHEN V(vce_out)=1.22022828542389 CROSS=1
.meas DC O124 FIND V(ic_out) WHEN V(vce_out)=1.22675330539058 CROSS=1
.meas DC O125 FIND V(ic_out) WHEN V(vce_out)=1.24632919502362 CROSS=1
.meas DC O126 FIND V(ic_out) WHEN V(vce_out)=1.27243093435631 CROSS=1
.meas DC O127 FIND V(ic_out) WHEN V(vce_out)=1.29853184395604 CROSS=1
.meas DC O128 FIND V(ic_out) WHEN V(vce_out)=1.33115860325542 CROSS=1
.meas DC O129 FIND V(ic_out) WHEN V(vce_out)=1.33768362322211 CROSS=1
.meas DC O130 FIND V(ic_out) WHEN V(vce_out)=1.37030955278854 CROSS=1
.meas DC O131 FIND V(ic_out) WHEN V(vce_out)=1.37683540248819 CROSS=1
.meas DC O132 FIND V(ic_out) WHEN V(vce_out)=1.40293631208792 CROSS=1
.meas DC O133 FIND V(ic_out) WHEN V(vce_out)=1.40946133205462 CROSS=1
.meas DC O134 FIND V(ic_out) WHEN V(vce_out)=1.4355630713873 CROSS=1
.meas DC O135 FIND V(ic_out) WHEN V(vce_out)=1.442088091354 CROSS=1
.meas DC O136 FIND V(ic_out) WHEN V(vce_out)=1.46166398098703 CROSS=1
.meas DC O137 FIND V(ic_out) WHEN V(vce_out)=1.46818900095373 CROSS=1
.meas DC O138 FIND V(ic_out) WHEN V(vce_out)=1.48776489058677 CROSS=1
.meas DC O139 FIND V(ic_out) WHEN V(vce_out)=1.49429074028642 CROSS=1
.meas DC O140 FIND V(ic_out) WHEN V(vce_out)=1.52039164988615 CROSS=1
.meas DC O141 FIND V(ic_out) WHEN V(vce_out)=1.52691666985284 CROSS=1
.meas DC O142 FIND V(ic_out) WHEN V(vce_out)=1.57259346908561 CROSS=1
.meas DC O143 FIND V(ic_out) WHEN V(vce_out)=1.61827109805134 CROSS=1
.meas DC O144 FIND V(ic_out) WHEN V(vce_out)=1.62479611801803 CROSS=1
.meas DC O145 FIND V(ic_out) WHEN V(vce_out)=1.66394789728411 CROSS=1
.meas DC O146 FIND V(ic_out) WHEN V(vce_out)=1.6704729172508 CROSS=1
.meas DC O147 FIND V(ic_out) WHEN V(vce_out)=1.70309967655018 CROSS=1
.meas DC O148 FIND V(ic_out) WHEN V(vce_out)=1.70962469651687 CROSS=1
.meas DC O149 FIND V(ic_out) WHEN V(vce_out)=1.73572560611661 CROSS=1
.meas DC O150 FIND V(ic_out) WHEN V(vce_out)=1.74225145581626 CROSS=1
.meas DC O151 FIND V(ic_out) WHEN V(vce_out)=1.77487738538268 CROSS=1
.meas DC O152 FIND V(ic_out) WHEN V(vce_out)=1.78140323508233 CROSS=1
.meas DC O153 FIND V(ic_out) WHEN V(vce_out)=1.81402916464876 CROSS=1
.meas DC O154 FIND V(ic_out) WHEN V(vce_out)=1.82055501434841 CROSS=1
.meas DC O155 FIND V(ic_out) WHEN V(vce_out)=1.84665592394814 CROSS=1
.meas DC O156 FIND V(ic_out) WHEN V(vce_out)=1.85318094391483 CROSS=1
.meas DC O157 FIND V(ic_out) WHEN V(vce_out)=1.88580770321421 CROSS=1
.meas DC O158 FIND V(ic_out) WHEN V(vce_out)=1.89233272318091 CROSS=1
.meas DC O159 FIND V(ic_out) WHEN V(vce_out)=1.92495948248029 CROSS=1
.meas DC O160 FIND V(ic_out) WHEN V(vce_out)=1.93148450244698 CROSS=1
.meas DC O161 FIND V(ic_out) WHEN V(vce_out)=1.95758541204671 CROSS=1
.meas DC O162 FIND V(ic_out) WHEN V(vce_out)=1.96411126174636 CROSS=1
.meas DC O163 FIND V(ic_out) WHEN V(vce_out)=1.99673719131279 CROSS=1
.meas DC O164 FIND V(ic_out) WHEN V(vce_out)=2.00326304101244 CROSS=1
.meas DC O165 FIND V(ic_out) WHEN V(vce_out)=2.04893984024521 CROSS=1
.meas DC O166 FIND V(ic_out) WHEN V(vce_out)=2.0554648602119 CROSS=1
.meas DC O167 FIND V(ic_out) WHEN V(vce_out)=2.08809161951128 CROSS=1
.meas DC O168 FIND V(ic_out) WHEN V(vce_out)=2.09461663947798 CROSS=1
.meas DC O169 FIND V(ic_out) WHEN V(vce_out)=2.13376841874405 CROSS=1
.meas DC O170 FIND V(ic_out) WHEN V(vce_out)=2.14029343871075 CROSS=1
.meas DC O171 FIND V(ic_out) WHEN V(vce_out)=2.17292019801013 CROSS=1
.meas DC O172 FIND V(ic_out) WHEN V(vce_out)=2.17944521797682 CROSS=1
.meas DC O173 FIND V(ic_out) WHEN V(vce_out)=2.20554612757655 CROSS=1
.meas DC O174 FIND V(ic_out) WHEN V(vce_out)=2.2120719772762 CROSS=1
.meas DC O175 FIND V(ic_out) WHEN V(vce_out)=2.24469790684263 CROSS=1
.meas DC O176 FIND V(ic_out) WHEN V(vce_out)=2.25122375654228 CROSS=1
.meas DC O177 FIND V(ic_out) WHEN V(vce_out)=2.29037553580835 CROSS=1
.meas DC O178 FIND V(ic_out) WHEN V(vce_out)=2.29690055577505 CROSS=1
.meas DC O179 FIND V(ic_out) WHEN V(vce_out)=2.32952731507443 CROSS=1
.meas DC O180 FIND V(ic_out) WHEN V(vce_out)=2.33605233504112 CROSS=1
.meas DC O181 FIND V(ic_out) WHEN V(vce_out)=2.36867826460755 CROSS=1
.meas DC O182 FIND V(ic_out) WHEN V(vce_out)=2.38825415424059 CROSS=1
.meas DC O183 FIND V(ic_out) WHEN V(vce_out)=2.4469818231397 CROSS=1
.meas DC O184 FIND V(ic_out) WHEN V(vce_out)=2.45350767283935 CROSS=1
.meas DC O185 FIND V(ic_out) WHEN V(vce_out)=2.48613360240577 CROSS=1
.meas DC O186 FIND V(ic_out) WHEN V(vce_out)=2.52528538167185 CROSS=1
.meas DC O187 FIND V(ic_out) WHEN V(vce_out)=2.53181040163854 CROSS=1
.meas DC O188 FIND V(ic_out) WHEN V(vce_out)=2.56443716093792 CROSS=1
.meas DC O189 FIND V(ic_out) WHEN V(vce_out)=2.57096218090462 CROSS=1
.meas DC O190 FIND V(ic_out) WHEN V(vce_out)=2.61663980987034 CROSS=1
.meas DC O191 FIND V(ic_out) WHEN V(vce_out)=2.62316482983704 CROSS=1
.meas DC O192 FIND V(ic_out) WHEN V(vce_out)=2.6753666490365 CROSS=1
.meas DC O193 FIND V(ic_out) WHEN V(vce_out)=2.68189249873615 CROSS=1
.meas DC O194 FIND V(ic_out) WHEN V(vce_out)=2.71451842830258 CROSS=1
.meas DC O195 FIND V(ic_out) WHEN V(vce_out)=2.72104427800223 CROSS=1
.meas DC O196 FIND V(ic_out) WHEN V(vce_out)=2.75367020756865 CROSS=1
.meas DC O197 FIND V(ic_out) WHEN V(vce_out)=2.7601960572683 CROSS=1
.meas DC O198 FIND V(ic_out) WHEN V(vce_out)=2.79934783653438 CROSS=1
.meas DC O199 FIND V(ic_out) WHEN V(vce_out)=2.8384987860675 CROSS=1
.meas DC O200 FIND V(ic_out) WHEN V(vce_out)=2.84502463576715 CROSS=1
.meas DC O201 FIND V(ic_out) WHEN V(vce_out)=2.91027732463295 CROSS=1
.meas DC O202 FIND V(ic_out) WHEN V(vce_out)=2.91680234459965 CROSS=1
.meas DC O203 FIND V(ic_out) WHEN V(vce_out)=2.98205586319841 CROSS=1
.meas DC O204 FIND V(ic_out) WHEN V(vce_out)=2.9885808831651 CROSS=1
.meas DC O205 FIND V(ic_out) WHEN V(vce_out)=3.04730855206422 CROSS=1
.meas DC O206 FIND V(ic_out) WHEN V(vce_out)=3.05383357203091 CROSS=1
.meas DC O207 FIND V(ic_out) WHEN V(vce_out)=3.11256124093002 CROSS=1
.meas DC O208 FIND V(ic_out) WHEN V(vce_out)=3.11908626089672 CROSS=1
.meas DC O209 FIND V(ic_out) WHEN V(vce_out)=3.16476306012949 CROSS=1
.meas DC O210 FIND V(ic_out) WHEN V(vce_out)=3.17128890982914 CROSS=1
.meas DC O211 FIND V(ic_out) WHEN V(vce_out)=3.20391483939556 CROSS=1
.meas DC O212 FIND V(ic_out) WHEN V(vce_out)=3.21044068909521 CROSS=1
.meas DC O213 FIND V(ic_out) WHEN V(vce_out)=3.25611748832798 CROSS=1
.meas DC O214 FIND V(ic_out) WHEN V(vce_out)=3.26264250829467 CROSS=1
.meas DC O215 FIND V(ic_out) WHEN V(vce_out)=3.36704697642656 CROSS=1
.meas DC O216 FIND V(ic_out) WHEN V(vce_out)=3.37357282612621 CROSS=1
.meas DC O217 FIND V(ic_out) WHEN V(vce_out)=3.41924962535898 CROSS=1
.meas DC O218 FIND V(ic_out) WHEN V(vce_out)=3.42577464532567 CROSS=1
.meas DC O219 FIND V(ic_out) WHEN V(vce_out)=3.46492642459174 CROSS=1
.meas DC O220 FIND V(ic_out) WHEN V(vce_out)=3.47145227429139 CROSS=1
.meas DC O221 FIND V(ic_out) WHEN V(vce_out)=3.51060322382451 CROSS=1
.meas DC O222 FIND V(ic_out) WHEN V(vce_out)=3.51712907352416 CROSS=1
.meas DC O223 FIND V(ic_out) WHEN V(vce_out)=3.56280587275693 CROSS=1
.meas DC O224 FIND V(ic_out) WHEN V(vce_out)=3.56933089272363 CROSS=1
.meas DC O225 FIND V(ic_out) WHEN V(vce_out)=3.61500852168935 CROSS=1
.meas DC O226 FIND V(ic_out) WHEN V(vce_out)=3.62153354165605 CROSS=1
.meas DC O227 FIND V(ic_out) WHEN V(vce_out)=3.66721034088881 CROSS=1
.meas DC O228 FIND V(ic_out) WHEN V(vce_out)=3.70636212015489 CROSS=1
.meas DC O229 FIND V(ic_out) WHEN V(vce_out)=3.79119069865373 CROSS=1
.meas DC O230 FIND V(ic_out) WHEN V(vce_out)=3.79771654835338 CROSS=1
.meas DC O231 FIND V(ic_out) WHEN V(vce_out)=3.9216969061183 CROSS=1
.meas DC O232 FIND V(ic_out) WHEN V(vce_out)=3.928221926085 CROSS=1
.meas DC O233 FIND V(ic_out) WHEN V(vce_out)=3.97389872531777 CROSS=1
.meas DC O234 FIND V(ic_out) WHEN V(vce_out)=3.98042374528446 CROSS=1
.meas DC O235 FIND V(ic_out) WHEN V(vce_out)=4.01957552455054 CROSS=1
.meas DC O236 FIND V(ic_out) WHEN V(vce_out)=4.02610137425019 CROSS=1
.meas DC O237 FIND V(ic_out) WHEN V(vce_out)=4.05872730381661 CROSS=1
.meas DC O238 FIND V(ic_out) WHEN V(vce_out)=4.06525315351626 CROSS=1
.meas DC O239 FIND V(ic_out) WHEN V(vce_out)=4.09787908308269 CROSS=1
.meas DC O240 FIND V(ic_out) WHEN V(vce_out)=4.10440493278234 CROSS=1
.meas DC O241 FIND V(ic_out) WHEN V(vce_out)=4.16313177194849 CROSS=1
.meas DC O242 FIND V(ic_out) WHEN V(vce_out)=4.23491031051395 CROSS=1
.meas DC O243 FIND V(ic_out) WHEN V(vce_out)=4.29363797941306 CROSS=1
.meas DC O244 FIND V(ic_out) WHEN V(vce_out)=4.30016299937976 CROSS=1
.meas DC O245 FIND V(ic_out) WHEN V(vce_out)=4.37194153794521 CROSS=1
.meas DC O246 FIND V(ic_out) WHEN V(vce_out)=4.37846655791191 CROSS=1
.meas DC O247 FIND V(ic_out) WHEN V(vce_out)=4.45024509647736 CROSS=1
.meas DC O248 FIND V(ic_out) WHEN V(vce_out)=4.45677011644406 CROSS=1
.meas DC O249 FIND V(ic_out) WHEN V(vce_out)=4.51549778534317 CROSS=1
.meas DC O250 FIND V(ic_out) WHEN V(vce_out)=4.52202280530987 CROSS=1
.meas DC O251 FIND V(ic_out) WHEN V(vce_out)=4.59380134387532 CROSS=1
.meas DC O252 FIND V(ic_out) WHEN V(vce_out)=4.60032636384202 CROSS=1
.meas DC O253 FIND V(ic_out) WHEN V(vce_out)=4.65905403274113 CROSS=1
.meas DC O254 FIND V(ic_out) WHEN V(vce_out)=4.66557905270782 CROSS=1
.meas DC O255 FIND V(ic_out) WHEN V(vce_out)=4.72430672160694 CROSS=1
.meas DC O256 FIND V(ic_out) WHEN V(vce_out)=4.79608443043944 CROSS=1
.meas DC O257 FIND V(ic_out) WHEN V(vce_out)=4.8613379490382 CROSS=1
.meas DC O258 FIND V(ic_out) WHEN V(vce_out)=4.90701474827097 CROSS=1
.meas DC O259 FIND V(ic_out) WHEN V(vce_out)=4.91353976823766 CROSS=1
.meas DC O260 FIND V(ic_out) WHEN V(vce_out)=4.95921656747043 CROSS=1
.meas DC O261 FIND V(ic_out) WHEN V(vce_out)=4.96574241717008 CROSS=1
.meas DC O262 FIND V(ic_out) WHEN V(vce_out)=5.01141921640285 CROSS=1
.meas DC O263 FIND V(ic_out) WHEN V(vce_out)=5.0962477949017 CROSS=1
.meas DC O264 FIND V(ic_out) WHEN V(vce_out)=5.22675400236627 CROSS=1
.meas DC O265 FIND V(ic_out) WHEN V(vce_out)=5.23327902233296 CROSS=1
.meas DC O266 FIND V(ic_out) WHEN V(vce_out)=5.29853171119877 CROSS=1
.meas DC O267 FIND V(ic_out) WHEN V(vce_out)=5.30505673116546 CROSS=1
.meas DC O268 FIND V(ic_out) WHEN V(vce_out)=5.35725938009788 CROSS=1
.meas DC O269 FIND V(ic_out) WHEN V(vce_out)=5.38336028969761 CROSS=1
.end
