* FJP5027 flyback | QSPICE | 65 kHz | measured circuit with 10 ohm clamp series resistance.
* Based on the supplied 400 us run. V13 with WAVL=1k suppresses modeled avalanche.
* E_ALL_MON tracks explicit L/C storage. Semiconductor terminal power may include
* changes in internal stored energy. ETA_WINDOW_PCT is the source-to-load ratio
* over this finite window. Check P_STORE_AVG and P_BAL_ERROR before interpreting it
* as steady-state efficiency. The idealized base driver has no supply overhead.
* Command sources drive behavioral expressions and deliver no electrical power.

V_BUS VBUS 0 {VBUS_DC}
.subckt Flyback_MV_29e872d030366567 P_DOT P_UNDOT S_DOT S_UNDOT P_CU P_CORE E_XFMR
R_P P_DOT p_leak 3.302050420572e+00
R_S s_current S_DOT 9.101546392467e-02
V_LKP_SENSE p_leak p_leak_l 0
L_LKP p_leak_l p_mag 1.694018661481e-05
V_MAG_SENSE p_mag p_mag_l 0
L_MAG p_mag_l P_UNDOT 7.437540558385e-04
E_SEC s_ideal S_UNDOT p_mag P_UNDOT 2.380952380952e-01
V_SENSE s_ideal s_current 0
F_REF p_mag P_UNDOT V_SENSE 2.380952380952e-01
R_CORE p_mag P_UNDOT 5.112204527117e+04
C_PS_D P_DOT S_DOT 3.836569162738e-11
C_PS_U P_UNDOT S_UNDOT 3.836569162738e-11
* High-impedance outputs for copper/core loss and stored energy.
B_CU P_CU 0 V={V(P_DOT,p_leak)*V(P_DOT,p_leak)/3.302050420572
+ + V(s_current,S_DOT)*V(s_current,S_DOT)/0.09101546392467}
B_CORE P_CORE 0 V={V(p_mag,P_UNDOT)*V(p_mag,P_UNDOT)/51122.04527117}
B_E_XFMR E_XFMR 0 V={0.5*(16.94018661481u*I(V_LKP_SENSE)*I(V_LKP_SENSE)
+ + 743.7540558385u*I(V_MAG_SENSE)*I(V_MAG_SENSE)
+ + 38.36569162738p*(V(P_DOT,S_DOT)*V(P_DOT,S_DOT)+V(P_UNDOT,S_UNDOT)*V(P_UNDOT,S_UNDOT)))}
.ends Flyback_MV_29e872d030366567
X_T1 VBUS SW SEC_RETURN SEC_RECT P_CU_MON P_CORE_MON E_XFMR_MON Flyback_MV_29e872d030366567
V_IC SW COL 0
V_ON CMD_ON 0 PULSE(0 {IB_FWD} {TDELAY} {TEDGE} {TEDGE} {TON} {TPER})
V_REV CMD_REV 0 PULSE(0 {IB_REV} {TREVERSE} {TEDGE} {TEDGE} {TREV} {TPER})
B_DRV 0 BDRV I={V(CMD_ON)-V(CMD_REV)}
B_LIMIT BDRV 0 I={(max(V(BDRV)-VDRV_MAX,0)+min(V(BDRV)-VDRV_MIN,0))/RCOMP}
R_BASE BDRV BFEED {RBASE}
R_BE BFEED 0 {RBE}
V_IB BFEED BASE 0
.model ES1J_PRELIM D(IS=1e-06 N=2.89631 RS=0.0613492 CJO=1.07486e-11 VJ=0.75 M=0.16 TT=8.528e-08 TNOM=25)
D_CLAMP N01 CLAMP ES1J_PRELIM
R_CLAMP VBUS CLAMP {RCLAMP}
C_CLAMP VBUS CLAMP {CCLAMP}
V_ID SEC_RECT SEC_ANODE 0
.model FR103_PRELIM D(IS=1.37919e-10 N=1.8 RS=0.25 CJO=2.70945e-11 VJ=0.8 M=0.33 TT=3.6851e-07 TNOM=25)
D_OUT SEC_ANODE VOUT FR103_PRELIM
R_ESR VOUT OUT_CAP {RESR}
C_OUT OUT_CAP SEC_RETURN {COUT}
R_LOAD VOUT SEC_RETURN {RLOAD}
R_SEC_REF SEC_RETURN 0 1G
B_VOUT VOUT_MON 0 V={V(VOUT,SEC_RETURN)}
B_IC IC_MON 0 V={I(V_IC)}
B_IB IB_MON 0 V={I(V_IB)}
B_ID ID_MON 0 V={I(V_ID)}
B_VCL VCL_MON 0 V={V(CLAMP,VBUS)}
B_VR_OUT VR_OUT_MON 0 V={V(VOUT,SEC_ANODE)}
B_VR_CL VR_CL_MON 0 V={V(CLAMP,N01)}
B_P_RCD P_RCD_MON 0 V={V(VCL_MON)*V(VCL_MON)/RCLAMP}
B_P_KEY P_KEY_MON 0 V={V(COL)*I(V_IC)+V(BASE)*I(V_IB)}
B_P_OUT P_OUT_MON 0 V={V(VOUT_MON)*V(VOUT_MON)/RLOAD}
B_P_FR P_FR_MON 0 V={V(SEC_ANODE,VOUT)*I(V_ID)}
RVD N01 SW {RVD_OHM}
.model FJP5027_MEXTRAM_V13_FLYBACK NPN( AQBO=0.297244498617917 AE=0 AB=1.69400323062251 AEPI=0.132493021759137 AEX=0.62 AC=2 DAIS=0 DVGBF=0.0547723812329828 DVGBR=0.0167856373543117 LEVEL=504 TREF=25 IS=3.63204984302532e-14 BF=34.9460276254282 VEF=805.802159113597 VER=42.0423371846927 IK=1.19667567511733 IBF=4.8783379259058e-12 MLF=1.50881604259697 BRI=5.89566175149349 IBR=9.19790477411798e-11 RE=0.001 RBC=0.0163401988720245 RBV=0.03 RCC=0.00103037374248808 RCV=0.233785344720853 SCRCV=4.49732594421438 IHC=3.37677753390719 AXI=0.62772326080186 CJE=2e-09 CJC=9.66455197629649e-11 PE=0.33 PC=0.33 VDE=0.75 VDC=0.75 TAUE=5e-09 TAUB=5e-09 VGB=1.25997562420926 VGC=1.11 VGJ=1.00691145909525 EXAVL=0 WAVL=1k RTH=0)
Q1 COL BASE 0 FJP5027_MEXTRAM_V13_FLYBACK
.param FSW=65K VBUS_DC=240 RLOAD=40
.param LM_REF=743.7540558385u IPK_CMD=0.61
.param IB_FWD=120m IB_REV=180m TREV=500n TEDGE=10n
.param RBASE=1 RBE=330 VDRV_MAX=3 VDRV_MIN=-2 RCOMP=100m
.param RCLAMP=47K CCLAMP=47n COUT=940u RESR=20m
.param VOUT_INIT=18 VCL_INIT=155
.param NCYC=24 NMEAS=4 DTMAX=25n
.param TPER={1/FSW}
.param TON={LM_REF*IPK_CMD/VBUS_DC}
.param TDELAY={2*TPER}
.param TREVERSE={TDELAY+TON+2*TEDGE}
.param TSTOP={TDELAY+NCYC*TPER}
.param TMEAS={TSTOP-NMEAS*TPER}
.param TPREV={TMEAS-NMEAS*TPER}
.ic V(SEC_RETURN)=0 V(OUT_CAP)={VOUT_INIT} V(CLAMP)={VBUS_DC+VCL_INIT}
.temp 25
.options reltol=1e-4 abstol=1e-10 vntol=1e-7
.tran 0 {TSTOP+1n} 0 {DTMAX}
.meas TRAN VOUT_AVG_PREV AVG V(VOUT_MON) FROM={TPREV} TO={TMEAS}
.meas TRAN VOUT_AVG AVG V(VOUT_MON) FROM={TMEAS} TO={TSTOP}
.meas TRAN VOUT_MIN MIN V(VOUT_MON) FROM={TMEAS} TO={TSTOP}
.meas TRAN VOUT_MAX MAX V(VOUT_MON) FROM={TMEAS} TO={TSTOP}
.meas TRAN VCE_PK MAX V(COL) FROM={TMEAS} TO={TSTOP}
.meas TRAN IC_PK MAX V(IC_MON) FROM={TMEAS} TO={TSTOP}
.meas TRAN IB_PK MAX V(IB_MON) FROM={TMEAS} TO={TSTOP}
.meas TRAN IB_REV_PK MIN V(IB_MON) FROM={TMEAS} TO={TSTOP}
.meas TRAN VBE_MIN MIN V(BASE) FROM={TMEAS} TO={TSTOP}
.meas TRAN VBE_MAX MAX V(BASE) FROM={TMEAS} TO={TSTOP}
.meas TRAN I_FR103_PK MAX V(ID_MON) FROM={TMEAS} TO={TSTOP}
.meas TRAN I_FR103_AVG AVG V(ID_MON) FROM={TMEAS} TO={TSTOP}
.meas TRAN VR_FR103_PK MAX V(VR_OUT_MON) FROM={TMEAS} TO={TSTOP}
.meas TRAN VR_ES1J_PK MAX V(VR_CL_MON) FROM={TMEAS} TO={TSTOP}
.meas TRAN V_RCD_CAP_PK MAX V(VCL_MON) FROM={TMEAS} TO={TSTOP}
.meas TRAN P_RCD_RES_AVG AVG V(P_RCD_MON) FROM={TMEAS} TO={TSTOP}
.meas TRAN P_KEY_TERM_AVG AVG V(P_KEY_MON) FROM={TMEAS} TO={TSTOP}
.meas TRAN P_FR103_AVG AVG V(P_FR_MON) FROM={TMEAS} TO={TSTOP}
.meas TRAN P_LOAD_AVG AVG V(P_OUT_MON) FROM={TMEAS} TO={TSTOP}
.param RVD_OHM=10

* Positive values are input power, load power, or device absorption.
* Monitor voltages numerically represent W, J, or A as indicated.
B_IIN IIN_MON 0 V={-I(V_BUS)}
B_IOUT IOUT_MON 0 V={V(VOUT_MON)/RLOAD}
B_P_BUS P_BUS_MON 0 V={V(VBUS)*V(IIN_MON)}
B_P_DRV P_DRV_MON 0 V={V(BDRV)*(V(CMD_ON)-V(CMD_REV))}
B_P_RVD P_RVD_MON 0 V={V(SW,N01)*V(SW,N01)/RVD_OHM}
B_P_ES1J P_ES1J_MON 0 V={V(N01,CLAMP)*V(SW,N01)/RVD_OHM}
B_P_ESR P_ESR_MON 0 V={V(VOUT,OUT_CAP)*V(VOUT,OUT_CAP)/RESR}
B_P_DRV_PASS P_DRV_PASS_MON 0 V={V(BDRV,BFEED)*V(BDRV,BFEED)/RBASE + V(BFEED)*V(BFEED)/RBE + V(BDRV)*(max(V(BDRV)-VDRV_MAX,0)+min(V(BDRV)-VDRV_MIN,0))/RCOMP}
B_P_REF P_REF_MON 0 V={V(SEC_RETURN)*V(SEC_RETURN)/1G}
B_E_CAPS E_CAPS_MON 0 V={0.5*(COUT*V(OUT_CAP,SEC_RETURN)*V(OUT_CAP,SEC_RETURN) + CCLAMP*V(CLAMP,VBUS)*V(CLAMP,VBUS))}
B_E_ALL E_ALL_MON 0 V={V(E_CAPS_MON)+V(E_XFMR_MON)}

* The transient ends 1 ns after TSTOP so energy samples bracket this window.
.meas TRAN IOUT_AVG AVG V(IOUT_MON) FROM={TMEAS} TO={TSTOP}
.meas TRAN P_BUS_AVG AVG V(P_BUS_MON) FROM={TMEAS} TO={TSTOP}
.meas TRAN P_DRV_AVG AVG V(P_DRV_MON) FROM={TMEAS} TO={TSTOP}
.meas TRAN P_RVD_AVG AVG V(P_RVD_MON) FROM={TMEAS} TO={TSTOP}
.meas TRAN P_ES1J_AVG AVG V(P_ES1J_MON) FROM={TMEAS} TO={TSTOP}
.meas TRAN P_ESR_AVG AVG V(P_ESR_MON) FROM={TMEAS} TO={TSTOP}
.meas TRAN P_DRV_PASS_AVG AVG V(P_DRV_PASS_MON) FROM={TMEAS} TO={TSTOP}
.meas TRAN P_CU_AVG AVG V(P_CU_MON) FROM={TMEAS} TO={TSTOP}
.meas TRAN P_CORE_AVG AVG V(P_CORE_MON) FROM={TMEAS} TO={TSTOP}
.meas TRAN P_REF_AVG AVG V(P_REF_MON) FROM={TMEAS} TO={TSTOP}
.meas TRAN E_STORE_START FIND V(E_ALL_MON) AT={TMEAS}
.meas TRAN E_STORE_END FIND V(E_ALL_MON) AT={TSTOP}
.meas TRAN WINDOW_S PARAM TSTOP-TMEAS
.meas TRAN P_STORE_AVG PARAM (E_STORE_END-E_STORE_START)/WINDOW_S
.meas TRAN P_IN_AVG PARAM P_BUS_AVG+P_DRV_AVG
.meas TRAN P_DEVICE_SUM PARAM P_KEY_TERM_AVG+P_FR103_AVG+P_ES1J_AVG+P_RCD_RES_AVG+P_RVD_AVG+P_ESR_AVG+P_DRV_PASS_AVG+P_CU_AVG+P_CORE_AVG+P_REF_AVG
.meas TRAN P_BAL_ERROR PARAM P_IN_AVG-P_LOAD_AVG-P_DEVICE_SUM-P_STORE_AVG
.meas TRAN ETA_WINDOW_PCT PARAM 100*P_LOAD_AVG/P_IN_AVG
.meas TRAN ETA_LOSS_ONLY_PCT PARAM 100*P_LOAD_AVG/(P_LOAD_AVG+P_DEVICE_SUM)

* Plots are listed from the bottom pane to the top pane.
.plot V(VOUT_MON)
.plot V(VR_OUT_MON)
.plot I(V_ID) I(R_LOAD)
.plot I(V_IC) I(V_IB)
.plot V(COL) V(VCL_MON)
.end
