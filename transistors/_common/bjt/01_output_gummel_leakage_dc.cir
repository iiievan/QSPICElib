* Reviewed topology snapshot for prepare-only mode. Normal runs netlist the QSCH.
V_SCAN scan 0 0
E_OUT out_drive 0 scan 0 {POL*VCE_SWEEP}
R_C out_drive out_feed {R_COLLECTOR}
V_IC_OUT out_feed c_out 0
I_BOUT 0 b_out {POL*IB_TEST}
X_OUT c_out b_out 0 0 DUT_BJT
V_CG c_g_feed 0 {POL*VCE_GUMMEL}
V_ICG c_g_feed c_gummel 0
B_VBG b_g_feed 0 V={POL*(VBE_START+(VBE_STOP-VBE_START)*V(scan))}
V_IBG b_g_feed b_gummel 0
X_GUMMEL c_gummel b_gummel 0 0 DUT_BJT
E_LEAK leak_drive 0 scan 0 {POL*VBLOCK_SCAN}
V_ICEO leak_drive c_iceo 0
R_BOPEN b_open 0 1T
X_ICEO c_iceo b_open 0 0 DUT_BJT
V_ICES leak_drive c_ices 0
X_ICES c_ices 0 0 0 DUT_BJT
B_VCEO vce_out 0 V={POL*V(c_out)}
B_ICO ic_out 0 V={POL*I(V_IC_OUT)}
B_VBE vbe 0 V={POL*V(b_gummel)}
B_ICG ic_gummel 0 V={POL*I(V_ICG)}
B_IBG ib_gummel 0 V={POL*I(V_IBG)}
B_VALID hfe_valid 0 V={if(V(ib_gummel)>100*IB_FLOOR,1,0)}
B_HFE hfe 0 V={if(V(hfe_valid)>0.5,V(ic_gummel)/max(V(ib_gummel),IB_FLOOR),0)}
B_VCEL vce_leak 0 V={POL*V(leak_drive)}
B_ICEO iceo 0 V={POL*I(V_ICEO)}
B_ICES ices 0 V={POL*I(V_ICES)}
.temp 25
.param VCE_SWEEP=10
.param R_COLLECTOR=1
.param IB_TEST=100u
.param IC_SAT_REF=5m
.param VCE_GUMMEL=5
.param VBE_START=0
.param VBE_STOP=0.9
.param VBLOCK_SCAN=20
.param IB_FLOOR=1p
.param SCAN_STEP=1m
.dc V_SCAN 0 1 {SCAN_STEP}
.options reltol=1e-5 abstol=1e-13 vntol=1e-8
.lib 00_device.cir
.end
