* 06 - BJT single-pulse resistive turn-off, QSPICE.
* Default device: FJP5027 MEXTRAM v13. Run from this bjt directory.
* To compare KSC5027, change the .lib path and Q_CORE model below.
* Keep the bench values identical between devices.
* For another BJT, replace the adapter block and set POL=1 (NPN) or -1 (PNP).
*
* Positive IC/IB are normalized to forward operation. Raw probe currents
* and raw terminal voltages give signed terminal power for either polarity.
* E_OFF_WINDOW is collector terminal energy in a fixed window, including
* storage time. E_OFF_TOTAL_WINDOW includes the base port as well.
* Compare the two window lengths and check IC_LATE before using E_OFF.
* Timing thresholds below refer to nominal load current VBUS/R_LOAD.
* Use IC_ON to check the plateau or replace IC_REFERENCE with its value.
* The 125 V / 45 mA / -0.5 A drive is a comparison condition. The
* finite base compliance and chosen pulse width are bench settings.

.param VBUS=125 R_LOAD=250
.param IB_ON=45m IB_OFF=-0.5 R_BASE=1
.param VBE_MAX=3 VBE_MIN=-2 R_COMPLIANCE=1m
.param T_DELAY=1u T_EDGE=5n T_ON=20u
.param ENERGY_WINDOW=10u T_MAX=1n
.param T_OFF={T_DELAY+T_EDGE+T_ON}
.param T_PRE={T_OFF-100n}
.param T_STOP={T_OFF+ENERGY_WINDOW+1u}
.param IC_REFERENCE={VBUS/R_LOAD}

V_BUS bus 0 {POL*VBUS}
R_LOAD bus c_feed {R_LOAD}
V_IC c_feed collector 0
X_DUT collector base 0 kelvin DUT_BJT

V_IB_CMD ib_cmd 0 PWL(0 0 {T_DELAY} 0 {T_DELAY+T_EDGE} {IB_ON} {T_OFF} {IB_ON} {T_OFF+T_EDGE} {IB_OFF})
B_IBSRC 0 b_drive I={POL*V(ib_cmd)}
B_LIMIT b_drive 0 I={POL*(max(POL*V(b_drive)-VBE_MAX,0)+min(POL*V(b_drive)-VBE_MIN,0))/R_COMPLIANCE}
R_B b_drive b_feed {R_BASE}
V_IB b_feed base 0

B_IC ic 0 V={POL*I(V_IC)}
B_IB ib 0 V={POL*I(V_IB)}
B_VCE vce 0 V={POL*V(collector)}
B_VBE vbe 0 V={POL*V(base)}
B_CF ic_ratio 0 V={V(ic)/IC_REFERENCE}
B_PC p_collector 0 V={V(collector)*I(V_IC)}
B_PB p_base 0 V={V(base)*I(V_IB)}
B_PT p_total 0 V={V(p_collector)+V(p_base)}

* Device adapter. The same C B E K interface is used by the other BJT benches.
.lib "../../BJT/FJP5027/FJP5027_MEXTRAM_v13.txt"
* .lib "../../BJT/FJP5027/FJP5027_KSC5027.txt"
.subckt DUT_BJT C B E K
Q_CORE C B E FJP5027_MEXTRAM_DC25_CANDIDATE_V3
* Q_CORE C B E KSC5027
R_K K E 1u
.ends DUT_BJT

.temp 25
.options reltol=1e-5 abstol=1e-12 vntol=1e-8
.tran 0 {T_STOP} 0 {T_MAX}
.plot V(vce) V(ic) V(ib) V(vbe) V(p_collector) V(p_base)

.meas TRAN IC_ON FIND V(ic) AT={T_PRE}
.meas TRAN IB_ON_ACTUAL FIND V(ib) AT={T_PRE}
.meas TRAN VCE_ON FIND V(vce) AT={T_PRE}
.meas TRAN IB_REVERSE_PEAK MIN V(ib) FROM={T_OFF} TO={T_OFF+ENERGY_WINDOW}
.meas TRAN T_STORAGE_IB_NOM TRIG V(ib)=0 FALL=1 TARG V(ic_ratio)=0.9 FALL=1
.meas TRAN T_FALL_IC_NOM TRIG V(ic_ratio)=0.9 FALL=1 TARG V(ic_ratio)=0.1 FALL=1
.meas TRAN E_OFF_HALF_WINDOW INTEG V(p_collector) FROM={T_OFF} TO={T_OFF+ENERGY_WINDOW/2}
.meas TRAN E_OFF_WINDOW INTEG V(p_collector) FROM={T_OFF} TO={T_OFF+ENERGY_WINDOW}
.meas TRAN E_OFF_BASE_WINDOW INTEG V(p_base) FROM={T_OFF} TO={T_OFF+ENERGY_WINDOW}
.meas TRAN E_OFF_TOTAL_WINDOW INTEG V(p_total) FROM={T_OFF} TO={T_OFF+ENERGY_WINDOW}
.meas TRAN IC_LATE FIND V(ic) AT={T_OFF+ENERGY_WINDOW}
.meas TRAN VCE_LATE FIND V(vce) AT={T_OFF+ENERGY_WINDOW}
.meas TRAN P_COLLECTOR_PEAK MAX V(p_collector) FROM={T_OFF} TO={T_OFF+ENERGY_WINDOW}
.meas TRAN T_STORAGE_IB_NOM TRIG V(ib_timing)=0 FALL=1 TARG V(ic_timing)=0.9 FALL=1
.meas TRAN T_FALL_IC_NOM TRIG V(ic_timing)=0.9 FALL=1 TARG V(ic_timing)=0.1 FALL=1
.end
