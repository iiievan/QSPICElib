* BJT adapter for bench 06. Connect to DUT_BJT in QSCH.
* Pins: C B E K. K is the Kelvin return, linked to E for three-pin devices.
* Select exactly one Q_CORE line. POL=1 for NPN and POL=-1 for PNP.
* KSC5027 also requires enabling its optional .lib line.
* BENCH_NPN_DEMO and BENCH_PNP_DEMO are synthetic examples.

.param POL=1

.lib "../../BJT/FJP5027/FJP5027_MEXTRAM_v13.txt"
* .lib "../../BJT/FJP5027/FJP5027_KSC5027.txt"

.model BENCH_NPN_DEMO NPN(Is=10f Bf=80 Vaf=60 Ikf=0.3 Br=3
+ Cje=30p Vje=0.75 Mje=0.33 Cjc=10p Vjc=0.75 Mjc=0.33
+ Tf=2n Tr=200n Rb=10 Rc=0.5 Re=0.05 Tnom=25)
.model BENCH_PNP_DEMO PNP(Is=10f Bf=80 Vaf=60 Ikf=0.3 Br=3
+ Cje=30p Vje=0.75 Mje=0.33 Cjc=10p Vjc=0.75 Mjc=0.33
+ Tf=2n Tr=200n Rb=10 Rc=0.5 Re=0.05 Tnom=25)

.subckt DUT_BJT C B E K
Q_CORE C B E FJP5027_MEXTRAM_DC25_CANDIDATE_V3
* Q_CORE C B E KSC5027
* Q_CORE C B E BENCH_NPN_DEMO
* Q_CORE C B E BENCH_PNP_DEMO
R_K K E 1u
.ends DUT_BJT
