* FET adapter include, NOT a standalone bench. No .end in this file.
* Default: existing user IRLML0100 candidate, copied without recalibration.
* All benches call X... D G S K DUT_FET; K is the driver/Kelvin return.
* For an ordinary three-terminal model use R_K below to join K and S.
* For a true Kelvin vendor subcircuit, map its actual pin order explicitly
* and REMOVE R_K if it would bypass the vendor's source lead impedance.
* For extra thermal pins read the vendor instructions; zero volts may mean
* zero degrees, NOT 'thermal simulation disabled'. Global .temp is not a
* substitute for a separately supplied vendor Tj/Tcase input.
*
* SELECT N: POL=1 and M_CORE ... IRLML0100 (active below).
* SELECT P: POL=-1 and M_CORE ... YJM05GP06A (alternative below).
* Change the polarity AND the adapter model together. Do not use abs()
* to conceal a wrong polarity or a wrong vendor terminal order.
.param POL=1

.model IRLML0100 VDMOS Vto=1.7 KP=17 Rd=85m Rs=85m Rg=1.3
+ lambda=0.01 Is=1n N=1.4 Rb=30m Eg=1.11 Cgs=277p
+ Cgdmin=13p Cgdmax=200p Cjo=75p Vj=0.8 M=0.45 Tnom=25
+ mfg="KEXIN" Vds=100 Ron=190m Qg=2.5n

* Existing P-channel engineering candidate; not newly accepted here.
.model YJM05GP06A VDMOS pchan Vto=-2 Kp=18 Rd=16.5m Rs=16.5m Rg=12
+ lambda=0.01 Is=1n N=1.4 Rb=20m Eg=1.11 XTI=3
+ Cgs=1030p Cgdmin=20p Cgdmax=350p Cjo=360p Vj=0.8 M=0.5 Tnom=25
+ mfg="YANGJIE" Vds=-60 Ron=55m Qg=18.7n

* For existing library files, instead of embedding the .model above:
* .include "../IRLML0100.txt"
* Candidate model files may be empty placeholders pending extraction.
* Do not rename this reference model to GaN/SiC and call it a vendor model.
.subckt DUT_FET D G S K
M_CORE D G S S IRLML0100
;M_CORE D G S S YJM05GP06A
R_K K S 1u
.ends DUT_FET
