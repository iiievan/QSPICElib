* BJT-01: Ic(Vce), Gummel, hFE and two different off-state leakage tests

* Output: fixed base current IB_TEST, collector voltage scanned via ballast.
* Gummel: Vbe sweep at fixed Vce; record signed Ic and Ib and hFE(Ic).
* Leakage: ICEO has an OPEN base (1T numerical reference); ICES has B=E.
* These two leakage definitions are not interchangeable.
* All four-terminal DUT_BJT instances use C B E K in that order.
* POL=1 NPN, POL=-1 PNP; data normalized positive in forward operation.
* Output-current crossing at IC_SAT_REF gives Vce for this PARTICULAR Ib;
* it is only a Vce(sat) acceptance point if the datasheet Ib is reproduced.
* Use separate .temp cases; no temperature coefficient is assumed correct.
.include "00_device.cir"
.temp 25
.param VCE_SWEEP=10
.param R_COLLECTOR=1
.param IB_TEST=100u
.param IC_SAT_REF=5m
.param VCE_GUMMEL=5
.param VBE_START=0
.param VBE_STOP=0.9
.param VBLOCK_SCAN=20
.param IB_FLOOR=1p
.param SCAN_STEP=1m

V_SCAN scan 0 0
E_COUT cout_drive 0 scan 0 {POL*VCE_SWEEP}
R_COUT cout_drive cout_feed {R_COLLECTOR}
V_ICOUT cout_feed c_out 0
I_BOUT 0 b_out {POL*IB_TEST}
X_OUT c_out b_out 0 0 DUT_BJT

V_CG cg_feed 0 {POL*VCE_GUMMEL}
V_ICG cg_feed c_gummel 0
B_VBE_DRIVE bg_drive 0 V={POL*(VBE_START+(VBE_STOP-VBE_START)*V(scan))}
V_IBG bg_drive b_gummel 0
X_GUMMEL c_gummel b_gummel 0 0 DUT_BJT

E_LEAK leak_drive 0 scan 0 {POL*VBLOCK_SCAN}
V_ICEO leak_drive c_open 0
R_BASE_OPEN b_open 0 1T
X_ICEO c_open b_open 0 0 DUT_BJT
V_ICES leak_drive c_short 0
X_ICES c_short 0 0 0 DUT_BJT

B_VCO vce_out 0 V={POL*V(c_out)}
B_ICO ic_out 0 V={POL*I(V_ICOUT)}
B_VBG vbe 0 V={POL*V(b_gummel)}
B_ICG ic_gummel 0 V={POL*I(V_ICG)}
B_IBG ib_gummel 0 V={POL*I(V_IBG)}
B_HFE hfe 0 V={V(ic_gummel)/max(V(ib_gummel),IB_FLOOR)}
B_VALID hfe_valid 0 V={if(V(ib_gummel)>100*IB_FLOOR,1,0)}
B_VL vce_leak 0 V={POL*V(leak_drive)}
B_ICEO iceo 0 V={POL*I(V_ICEO)}
B_ICES ices 0 V={POL*I(V_ICES)}
.options reltol=1e-5 abstol=1e-13 vntol=1e-8
.dc V_SCAN 0 1 {SCAN_STEP}
.save V(scan) V(vce_out) V(ic_out) V(vbe) V(ic_gummel) V(ib_gummel) V(hfe) V(hfe_valid) V(vce_leak) V(iceo) V(ices)
.meas DC VCE_AT_IC FIND V(vce_out) WHEN V(ic_out)={IC_SAT_REF} CROSS=1
.meas DC ICEO_END FIND V(iceo) AT=1
.meas DC ICES_END FIND V(ices) AT=1
.meas DC IC_GUMMEL_END FIND V(ic_gummel) AT=1
.meas DC IB_GUMMEL_END FIND V(ib_gummel) AT=1
.end
