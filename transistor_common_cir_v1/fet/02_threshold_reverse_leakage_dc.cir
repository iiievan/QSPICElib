* FET-02: diode-connected threshold, reverse conduction, drain/gate leakage

* Four independent DUTs; one dimensionless scan drives their bias voltages.
* Threshold: D=G, voltage sweep + ballast; actual terminal Vgs measured.
* Reverse conduction: VGS_REVERSE may be 0, negative (SiC off), or on.
* For GaN this is CHANNEL reverse conduction, NOT a fictitious body diode.
* Off-state drain branch: Vgs=VGS_OFF; plot leakage versus actual Vds.
* Gate-leakage branch: Vds=0. Some models omit Igss/breakdown altogether.
* No avalanche/SOA acceptance follows from this non-destructive DC scan.
.include "00_device.cir"
.temp 25
.param VTH_SCAN=5
.param R_TH=100
.param I_TH=250u
.param VREVERSE_SCAN=3
.param R_REVERSE=1
.param I_REVERSE=0.5
.param VGS_REVERSE=0
.param VBLOCK_SCAN=50
.param VGS_OFF=0
.param VGATE_LEAK_SCAN=4.5
.param SCAN_STEP=1m

V_SCAN scan 0 0
E_TH th_drive 0 scan 0 {POL*VTH_SCAN}
R_TH th_drive th_feed {R_TH}
V_ITH th_feed th 0
X_TH th th 0 0 DUT_FET

E_REV rev_drive 0 scan 0 {-POL*VREVERSE_SCAN}
R_REV rev_drive rev_feed {R_REVERSE}
V_IREV rev_feed d_reverse 0
V_GREV g_reverse 0 {POL*VGS_REVERSE}
X_REV d_reverse g_reverse 0 0 DUT_FET

E_OFF off_drive 0 scan 0 {POL*VBLOCK_SCAN}
V_IOFF off_drive d_off 0
V_GOFF g_off 0 {POL*VGS_OFF}
X_OFF d_off g_off 0 0 DUT_FET

E_GL gl_drive 0 scan 0 {POL*VGATE_LEAK_SCAN}
V_IGL gl_drive g_leak 0
X_GATE_LEAK 0 g_leak 0 0 DUT_FET

B_VTH vth 0 V={POL*V(th)}
B_ITH ith 0 V={POL*I(V_ITH)}
B_VREV vsd 0 V={-POL*V(d_reverse)}
B_IREV isd 0 V={-POL*I(V_IREV)}
B_VOFF vds_off 0 V={POL*V(d_off)}
B_IOFF idss 0 V={POL*I(V_IOFF)}
B_VGL vgs_leak 0 V={POL*V(g_leak)}
B_IGL igss 0 V={POL*I(V_IGL)}
.options reltol=1e-5 abstol=1e-13 vntol=1e-8
.dc V_SCAN 0 1 {SCAN_STEP}
.save V(scan) V(vth) V(ith) V(vsd) V(isd) V(vds_off) V(idss) V(vgs_leak) V(igss)
.meas DC VTH_AT_ITH FIND V(vth) WHEN V(ith)={I_TH} CROSS=1
.meas DC VSD_AT_IS FIND V(vsd) WHEN V(isd)={I_REVERSE} CROSS=1
.meas DC IDSS_AT_END FIND V(idss) AT=1
.meas DC IGSS_AT_END FIND V(igss) AT=1
.meas DC ACTUAL_BLOCKING_V FIND V(vds_off) AT=1
.end
