* BJT-02: Cobo with emitter open, Cibo with collector open

* These are BJT open-terminal datasheet conditions, NOT FET Ciss/Coss.
* Cobo: reverse C-B bias, base grounded, emitter open.
* Cibo: reverse E-B bias, base grounded, collector open.
* The 1T reference resistors approximate an open terminal for DC stability.
* AC_AMPL=1 is a linearization amplitude, not a 1-V large-signal excursion.
* Only DC bias changes with POL; AC probe signs are not polarity-flipped.
* C[F] = imag(V(i_cobo/cibo))/(2*pi*f*AC_AMPL).
* FJP5027 specifies Cob at VCB=10V, emitter open, f=1MHz.
* Do not invent a Cibo acceptance target where the datasheet gives none.
.include "00_device.cir"
.temp 25
.param VCB_BIAS=10
.param VEB_BIAS=1
.param AC_AMPL=1
.param F_MIN=100k
.param F_MAX=10Meg
.param F_TEST=1Meg

V_CO co_drive 0 DC {POL*VCB_BIAS} AC {AC_AMPL}
V_CO_SENSE co_drive c_out 0
R_EOPEN e_open 0 1T
X_CO c_out 0 e_open e_open DUT_BJT

V_CI ci_drive 0 DC {POL*VEB_BIAS} AC {AC_AMPL}
V_CI_SENSE ci_drive e_in 0
R_COPEN c_open 0 1T
X_CI c_open 0 e_in e_in DUT_BJT

B_CO i_cobo 0 V={I(V_CO_SENSE)}
B_CI i_cibo 0 V={I(V_CI_SENSE)}
.options reltol=1e-5 abstol=1e-13 vntol=1e-8
.ac dec 40 {F_MIN} {F_MAX}
.save V(i_cobo) V(i_cibo)
.meas AC COBO_I_IM FIND imag(V(i_cobo)) AT={F_TEST}
.meas AC CIBO_I_IM FIND imag(V(i_cibo)) AT={F_TEST}
.end
